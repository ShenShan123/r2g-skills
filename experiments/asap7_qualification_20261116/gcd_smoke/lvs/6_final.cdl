* CDL Netlist generated by OpenROAD

*.BUSDELIMITER [

.SUBCKT gcd clk req_msg[0] req_msg[10] req_msg[11] req_msg[12]
+ req_msg[13] req_msg[14] req_msg[15] req_msg[16] req_msg[17]
+ req_msg[18] req_msg[19] req_msg[1] req_msg[20] req_msg[21]
+ req_msg[22] req_msg[23] req_msg[24] req_msg[25] req_msg[26]
+ req_msg[27] req_msg[28] req_msg[29] req_msg[2] req_msg[30]
+ req_msg[31] req_msg[3] req_msg[4] req_msg[5] req_msg[6] req_msg[7]
+ req_msg[8] req_msg[9] req_rdy req_val reset resp_msg[0] resp_msg[10]
+ resp_msg[11] resp_msg[12] resp_msg[13] resp_msg[14] resp_msg[15]
+ resp_msg[1] resp_msg[2] resp_msg[3] resp_msg[4] resp_msg[5]
+ resp_msg[6] resp_msg[7] resp_msg[8] resp_msg[9] resp_rdy resp_val
+ VDD VSS
X_331_ _001_ VDD VSS dpath.a_lt_b$in0\[15\] INVx1_ASAP7_75t_R
X_332_ _019_ VDD VSS dpath.a_lt_b$in0\[1\] INVx1_ASAP7_75t_R
X_333_ _003_ VDD VSS dpath.a_lt_b$in0\[2\] INVx1_ASAP7_75t_R
X_334_ _004_ VDD VSS dpath.a_lt_b$in0\[3\] INVx1_ASAP7_75t_R
X_335_ _005_ VDD VSS dpath.a_lt_b$in0\[4\] INVx1_ASAP7_75t_R
X_336_ _006_ VDD VSS dpath.a_lt_b$in0\[5\] INVx1_ASAP7_75t_R
X_337_ _007_ VDD VSS dpath.a_lt_b$in0\[6\] INVx1_ASAP7_75t_R
X_338_ _008_ VDD VSS dpath.a_lt_b$in0\[7\] INVx1_ASAP7_75t_R
X_339_ _009_ VDD VSS dpath.a_lt_b$in0\[8\] INVx1_ASAP7_75t_R
X_340_ _010_ VDD VSS dpath.a_lt_b$in0\[9\] INVx1_ASAP7_75t_R
X_341_ _011_ VDD VSS dpath.a_lt_b$in0\[10\] INVx1_ASAP7_75t_R
X_342_ _012_ VDD VSS dpath.a_lt_b$in0\[11\] INVx1_ASAP7_75t_R
X_343_ _013_ VDD VSS dpath.a_lt_b$in0\[12\] INVx1_ASAP7_75t_R
X_344_ _014_ VDD VSS dpath.a_lt_b$in0\[13\] INVx1_ASAP7_75t_R
X_345_ _015_ VDD VSS dpath.a_lt_b$in0\[14\] INVx1_ASAP7_75t_R
X_346_ _069_ VDD VSS dpath.a_lt_b$in1\[0\] INVx1_ASAP7_75t_R
X_347_ _021_ VDD VSS dpath.a_lt_b$in1\[1\] INVx1_ASAP7_75t_R
X_348_ _020_ VDD VSS _018_ INVx1_ASAP7_75t_R
X_349_ _000_ VDD VSS _108_ INVx1_ASAP7_75t_R
X_350_ _108_ _063_ _062_ VDD VSS _109_ OA21x2_ASAP7_75t_R
X_351_ _036_ _039_ _042_ VDD VSS _110_ OR3x1_ASAP7_75t_R
X_352_ _039_ _041_ _038_ VDD VSS _111_ OA21x2_ASAP7_75t_R
X_353_ _036_ _111_ _035_ VDD VSS _112_ OA21x2_ASAP7_75t_R
X_354_ _109_ _110_ _112_ VDD VSS _113_ OA21x2_ASAP7_75t_R
X_355_ _027_ _113_ VDD VSS net49 XOR2x2_ASAP7_75t_R
X_356_ _018_ _072_ _071_ VDD VSS _114_ OA21x2_ASAP7_75t_R
X_357_ _063_ _114_ _062_ VDD VSS _115_ OA21x2_ASAP7_75t_R
X_358_ _039_ _042_ VDD VSS _116_ OR2x2_ASAP7_75t_R
X_359_ _115_ _116_ _111_ VDD VSS _117_ OA21x2_ASAP7_75t_R
X_360_ _036_ _117_ VDD VSS net48 XOR2x2_ASAP7_75t_R
X_361_ _042_ _109_ _041_ VDD VSS _118_ OA21x2_ASAP7_75t_R
X_362_ _039_ _118_ VDD VSS net47 XOR2x2_ASAP7_75t_R
X_363_ _042_ _115_ VDD VSS net46 XOR2x2_ASAP7_75t_R
X_364_ _000_ _063_ VDD VSS net45 XNOR2x2_ASAP7_75t_R
X_365_ _070_ VDD VSS dpath.a_lt_b$in0\[0\] INVx1_ASAP7_75t_R
Xinput17 req_msg[24] VDD VSS net17 BUFx2_ASAP7_75t_R
X_367_ net56 VDD VSS net36 INVx1_ASAP7_75t_R
Xinput16 req_msg[23] VDD VSS net16 BUFx2_ASAP7_75t_R
Xinput15 req_msg[22] VDD VSS net15 BUFx2_ASAP7_75t_R
Xinput14 req_msg[21] VDD VSS net14 BUFx2_ASAP7_75t_R
X_371_ _030_ _033_ VDD VSS _124_ OR2x2_ASAP7_75t_R
X_372_ _057_ _051_ _060_ _124_ VDD VSS _125_ OR4x1_ASAP7_75t_R
X_373_ _027_ _125_ VDD VSS _126_ OR2x2_ASAP7_75t_R
X_374_ _026_ _033_ _032_ VDD VSS _127_ OA21x2_ASAP7_75t_R
X_375_ _057_ _030_ _051_ _060_ _127_ VDD VSS _128_ OR5x1_ASAP7_75t_R
X_376_ _056_ _051_ _128_ _050_ VDD VSS _129_ OA211x2_ASAP7_75t_R
X_377_ _029_ _060_ _059_ VDD VSS _130_ OA21x2_ASAP7_75t_R
X_378_ _057_ _051_ _130_ VDD VSS _131_ OR3x4_ASAP7_75t_R
X_379_ _113_ _126_ _129_ _131_ VDD VSS _132_ OA211x2_ASAP7_75t_R
X_380_ _045_ _024_ VDD VSS _133_ OR2x2_ASAP7_75t_R
X_381_ _054_ _048_ _133_ VDD VSS _134_ OR3x2_ASAP7_75t_R
Xinput13 req_msg[20] VDD VSS net13 BUFx2_ASAP7_75t_R
X_383_ _002_ VDD VSS _136_ INVx1_ASAP7_75t_R
X_384_ _044_ _024_ _023_ VDD VSS _137_ OA21x2_ASAP7_75t_R
X_385_ _048_ _137_ _047_ VDD VSS _138_ OA21x2_ASAP7_75t_R
X_386_ _054_ _138_ _053_ VDD VSS _139_ OA21x2_ASAP7_75t_R
X_387_ _136_ _139_ VDD VSS _140_ AND2x2_ASAP7_75t_R
X_388_ _132_ _134_ _140_ VDD VSS _141_ OAI21x1_ASAP7_75t_R
Xinput12 req_msg[1] VDD VSS net12 BUFx2_ASAP7_75t_R
X_390_ net36 _141_ VDD VSS _067_ OR2x4_ASAP7_75t_R
X_391_ _067_ VDD VSS ctrl$a_mux_sel\[1\] INVx2_ASAP7_75t_R
X_392_ _132_ _133_ _137_ VDD VSS _143_ OA21x2_ASAP7_75t_R
X_393_ _048_ _143_ VDD VSS net42 XOR2x2_ASAP7_75t_R
X_394_ _027_ _036_ _125_ VDD VSS _144_ OR3x1_ASAP7_75t_R
X_395_ _059_ _057_ _056_ VDD VSS _145_ OA21x2_ASAP7_75t_R
X_396_ _027_ _035_ _026_ VDD VSS _146_ OA21x2_ASAP7_75t_R
X_397_ _030_ _032_ _029_ VDD VSS _147_ OA21x2_ASAP7_75t_R
X_398_ _124_ _146_ _147_ VDD VSS _148_ OA21x2_ASAP7_75t_R
X_399_ _057_ _051_ _060_ _148_ VDD VSS _149_ OR4x1_ASAP7_75t_R
X_400_ _051_ _145_ _149_ VDD VSS _150_ OA21x2_ASAP7_75t_R
X_401_ _117_ _144_ _150_ VDD VSS _151_ OAI21x1_ASAP7_75t_R
X_402_ _045_ VDD VSS _152_ INVx1_ASAP7_75t_R
X_403_ _152_ _024_ VDD VSS _153_ AND2x2_ASAP7_75t_R
X_404_ _050_ _045_ _044_ VDD VSS _154_ OAI21x1_ASAP7_75t_R
X_405_ _024_ _154_ VDD VSS _155_ NOR2x1_ASAP7_75t_R
X_406_ _117_ _144_ _155_ _150_ VDD VSS _156_ OA211x2_ASAP7_75t_R
X_407_ _151_ _153_ _156_ VDD VSS _157_ AO21x1_ASAP7_75t_R
X_408_ _024_ _154_ VDD VSS _158_ AND2x2_ASAP7_75t_R
X_409_ _045_ _155_ _158_ VDD VSS _159_ AO21x1_ASAP7_75t_R
X_410_ _157_ _159_ VDD VSS net41 OR2x2_ASAP7_75t_R
X_411_ _152_ _132_ VDD VSS net40 XNOR2x2_ASAP7_75t_R
X_412_ _051_ VDD VSS _160_ INVx1_ASAP7_75t_R
X_413_ _057_ _060_ _124_ VDD VSS _161_ OR3x1_ASAP7_75t_R
X_414_ _115_ _116_ _146_ _111_ VDD VSS _162_ OA211x2_ASAP7_75t_R
X_415_ _027_ _036_ _146_ VDD VSS _163_ OA21x2_ASAP7_75t_R
X_416_ _162_ _163_ VDD VSS _164_ OR2x2_ASAP7_75t_R
X_417_ _060_ _147_ _059_ VDD VSS _165_ OA21x2_ASAP7_75t_R
X_418_ _057_ _165_ _056_ VDD VSS _166_ OA21x2_ASAP7_75t_R
X_419_ _161_ _164_ _166_ VDD VSS _167_ OA21x2_ASAP7_75t_R
X_420_ _160_ _167_ VDD VSS net39 XNOR2x2_ASAP7_75t_R
X_421_ _060_ VDD VSS _168_ INVx1_ASAP7_75t_R
X_422_ _032_ _033_ _030_ VDD VSS _169_ AO21x1_ASAP7_75t_R
X_423_ _027_ _113_ _032_ _026_ VDD VSS _170_ OA211x2_ASAP7_75t_R
X_424_ _169_ _170_ _029_ VDD VSS _171_ OAI21x1_ASAP7_75t_R
X_425_ _059_ VDD VSS _172_ INVx1_ASAP7_75t_R
X_426_ _168_ _171_ _172_ VDD VSS _173_ AO21x1_ASAP7_75t_R
X_427_ _057_ _173_ VDD VSS net38 XNOR2x2_ASAP7_75t_R
X_428_ _124_ _162_ _163_ _147_ VDD VSS _174_ OA31x2_ASAP7_75t_R
X_429_ _168_ _174_ VDD VSS net52 XNOR2x2_ASAP7_75t_R
X_430_ _027_ _113_ _026_ VDD VSS _175_ OA21x2_ASAP7_75t_R
X_431_ _033_ _175_ _032_ VDD VSS _176_ OAI21x1_ASAP7_75t_R
X_432_ _030_ _176_ VDD VSS net51 XNOR2x2_ASAP7_75t_R
X_433_ _033_ _164_ VDD VSS net50 XOR2x2_ASAP7_75t_R
X_434_ _048_ _125_ _133_ VDD VSS _177_ OR3x1_ASAP7_75t_R
X_435_ _051_ _048_ _133_ VDD VSS _178_ OR3x1_ASAP7_75t_R
X_436_ _050_ _045_ _044_ VDD VSS _179_ OA21x2_ASAP7_75t_R
X_437_ _024_ _179_ _023_ VDD VSS _180_ OA21x2_ASAP7_75t_R
X_438_ _048_ _180_ _047_ VDD VSS _181_ OA21x2_ASAP7_75t_R
X_439_ _166_ _178_ _181_ VDD VSS _182_ OA21x2_ASAP7_75t_R
X_440_ _162_ _163_ _177_ _182_ VDD VSS _183_ OA31x2_ASAP7_75t_R
X_441_ _054_ _183_ VDD VSS net43 XOR2x2_ASAP7_75t_R
X_442_ _132_ _134_ _139_ VDD VSS _184_ OA21x2_ASAP7_75t_R
X_443_ _002_ net36 _184_ VDD VSS _064_ OR3x1_ASAP7_75t_R
X_444_ _064_ VDD VSS ctrl$a_mux_sel\[0\] INVx1_ASAP7_75t_R
Xinput11 req_msg[19] VDD VSS net11 BUFx2_ASAP7_75t_R
X_446_ _136_ _184_ VDD VSS _185_ AND2x4_ASAP7_75t_R
Xinput10 req_msg[18] VDD VSS net10 BUFx2_ASAP7_75t_R
Xinput9 req_msg[17] VDD VSS net9 BUFx2_ASAP7_75t_R
X_449_ dpath.a_lt_b$in0\[14\] net56 VDD VSS _188_ AND2x2_ASAP7_75t_R
X_450_ _046_ VDD VSS _189_ INVx1_ASAP7_75t_R
Xinput8 req_msg[16] VDD VSS net8 BUFx2_ASAP7_75t_R
X_452_ _189_ net56 _141_ VDD VSS _191_ AND3x1_ASAP7_75t_R
X_453_ net6 net36 _185_ _188_ _191_ VDD VSS _076_ AO221x2_ASAP7_75t_R
X_454_ dpath.a_lt_b$in0\[13\] net56 VDD VSS _192_ AND2x2_ASAP7_75t_R
X_455_ _022_ VDD VSS _193_ INVx1_ASAP7_75t_R
X_456_ _193_ net56 _141_ VDD VSS _194_ AND3x1_ASAP7_75t_R
X_457_ net36 net5 _185_ _192_ _194_ VDD VSS _077_ AO221x2_ASAP7_75t_R
X_458_ dpath.a_lt_b$in0\[12\] net56 VDD VSS _195_ AND2x2_ASAP7_75t_R
X_459_ _043_ VDD VSS _196_ INVx1_ASAP7_75t_R
X_460_ _196_ net56 _141_ VDD VSS _197_ AND3x1_ASAP7_75t_R
X_461_ net36 net4 _185_ _195_ _197_ VDD VSS _078_ AO221x2_ASAP7_75t_R
X_462_ dpath.a_lt_b$in0\[11\] net56 VDD VSS _198_ AND2x2_ASAP7_75t_R
X_463_ _049_ VDD VSS _199_ INVx1_ASAP7_75t_R
X_464_ _199_ net56 _141_ VDD VSS _200_ AND3x1_ASAP7_75t_R
X_465_ net36 net3 _185_ _198_ _200_ VDD VSS _079_ AO221x2_ASAP7_75t_R
Xinput7 req_msg[15] VDD VSS net7 BUFx2_ASAP7_75t_R
X_467_ dpath.a_lt_b$in0\[10\] net56 VDD VSS _202_ AND2x2_ASAP7_75t_R
X_468_ _055_ VDD VSS _203_ INVx1_ASAP7_75t_R
X_469_ _203_ net56 _141_ VDD VSS _204_ AND3x1_ASAP7_75t_R
X_470_ net36 net2 _185_ _202_ _204_ VDD VSS _080_ AO221x2_ASAP7_75t_R
X_471_ dpath.a_lt_b$in0\[9\] net56 VDD VSS _205_ AND2x2_ASAP7_75t_R
X_472_ _058_ VDD VSS _206_ INVx1_ASAP7_75t_R
X_473_ _206_ net56 _141_ VDD VSS _207_ AND3x1_ASAP7_75t_R
X_474_ net36 net32 _185_ _205_ _207_ VDD VSS _081_ AO221x2_ASAP7_75t_R
X_475_ dpath.a_lt_b$in0\[8\] net56 VDD VSS _208_ AND2x2_ASAP7_75t_R
X_476_ _028_ VDD VSS _209_ INVx1_ASAP7_75t_R
X_477_ _209_ net56 _141_ VDD VSS _210_ AND3x1_ASAP7_75t_R
X_478_ net36 net31 _185_ _208_ _210_ VDD VSS _082_ AO221x2_ASAP7_75t_R
X_479_ dpath.a_lt_b$in0\[7\] net56 VDD VSS _211_ AND2x2_ASAP7_75t_R
X_480_ _031_ VDD VSS _212_ INVx1_ASAP7_75t_R
X_481_ _212_ net56 _141_ VDD VSS _213_ AND3x1_ASAP7_75t_R
X_482_ net36 net30 _185_ _211_ _213_ VDD VSS _083_ AO221x2_ASAP7_75t_R
X_483_ dpath.a_lt_b$in0\[6\] net56 VDD VSS _214_ AND2x2_ASAP7_75t_R
X_484_ _025_ VDD VSS _215_ INVx1_ASAP7_75t_R
X_485_ _215_ net56 _141_ VDD VSS _216_ AND3x1_ASAP7_75t_R
X_486_ net36 net29 _185_ _214_ _216_ VDD VSS _084_ AO221x1_ASAP7_75t_R
X_487_ dpath.a_lt_b$in0\[5\] net56 VDD VSS _217_ AND2x2_ASAP7_75t_R
X_488_ _034_ VDD VSS _218_ INVx1_ASAP7_75t_R
X_489_ _218_ net56 _141_ VDD VSS _219_ AND3x1_ASAP7_75t_R
X_490_ net36 net28 _185_ _217_ _219_ VDD VSS _085_ AO221x1_ASAP7_75t_R
X_491_ dpath.a_lt_b$in0\[4\] net56 VDD VSS _220_ AND2x2_ASAP7_75t_R
X_492_ _037_ VDD VSS _221_ INVx1_ASAP7_75t_R
X_493_ _221_ net56 _141_ VDD VSS _222_ AND3x1_ASAP7_75t_R
X_494_ net36 net27 _185_ _220_ _222_ VDD VSS _086_ AO221x1_ASAP7_75t_R
X_495_ dpath.a_lt_b$in0\[3\] net56 VDD VSS _223_ AND2x2_ASAP7_75t_R
X_496_ _040_ VDD VSS _224_ INVx1_ASAP7_75t_R
X_497_ _224_ net56 _141_ VDD VSS _225_ AND3x1_ASAP7_75t_R
X_498_ net36 net26 _185_ _223_ _225_ VDD VSS _087_ AO221x1_ASAP7_75t_R
X_499_ dpath.a_lt_b$in0\[2\] net56 VDD VSS _226_ AND2x2_ASAP7_75t_R
X_500_ _061_ VDD VSS _227_ INVx1_ASAP7_75t_R
X_501_ _227_ net56 _141_ VDD VSS _228_ AND3x1_ASAP7_75t_R
X_502_ net36 net23 _185_ _226_ _228_ VDD VSS _088_ AO221x1_ASAP7_75t_R
X_503_ dpath.a_lt_b$in0\[1\] net56 VDD VSS _229_ AND2x2_ASAP7_75t_R
X_504_ dpath.a_lt_b$in1\[1\] net56 _141_ VDD VSS _230_ AND3x1_ASAP7_75t_R
X_505_ net36 net12 _185_ _229_ _230_ VDD VSS _089_ AO221x1_ASAP7_75t_R
X_506_ dpath.a_lt_b$in0\[0\] net56 VDD VSS _231_ AND2x2_ASAP7_75t_R
X_507_ dpath.a_lt_b$in1\[0\] net56 _141_ VDD VSS _232_ AND3x1_ASAP7_75t_R
X_508_ net36 net1 _185_ _231_ _232_ VDD VSS _090_ AO221x1_ASAP7_75t_R
X_509_ _002_ net56 VDD VSS _233_ AND2x2_ASAP7_75t_R
Xinput6 req_msg[14] VDD VSS net6 BUFx2_ASAP7_75t_R
Xinput5 req_msg[13] VDD VSS net5 BUFx2_ASAP7_75t_R
Xinput4 req_msg[12] VDD VSS net4 BUFx2_ASAP7_75t_R
X_513_ _068_ VDD VSS _237_ INVx1_ASAP7_75t_R
X_514_ _002_ net56 VDD VSS _238_ NAND2x1_ASAP7_75t_R
X_515_ _237_ _238_ VDD VSS _239_ AND2x2_ASAP7_75t_R
X_516_ net24 net55 _239_ VDD VSS _240_ OA21x2_ASAP7_75t_R
X_517_ net55 VDD VSS _241_ INVx1_ASAP7_75t_R
Xinput3 req_msg[11] VDD VSS net3 BUFx2_ASAP7_75t_R
X_519_ net24 _241_ VDD VSS _243_ AND2x2_ASAP7_75t_R
X_520_ _065_ VDD VSS _244_ INVx1_ASAP7_75t_R
Xinput2 req_msg[10] VDD VSS net2 BUFx2_ASAP7_75t_R
X_522_ _189_ _244_ net55 VDD VSS _246_ AND3x1_ASAP7_75t_R
Xinput1 req_msg[0] VDD VSS net1 BUFx2_ASAP7_75t_R
X_524_ _243_ _246_ _238_ VDD VSS _248_ OA21x2_ASAP7_75t_R
X_525_ dpath.a_lt_b$in0\[14\] _233_ _240_ net42 _248_ VDD
+ VSS _091_ AO221x1_ASAP7_75t_R
X_526_ _066_ net22 _239_ VDD VSS _249_ OA21x2_ASAP7_75t_R
X_527_ _241_ net22 VDD VSS _250_ AND2x2_ASAP7_75t_R
X_528_ _193_ _244_ _066_ VDD VSS _251_ AND3x1_ASAP7_75t_R
X_529_ _250_ _251_ _238_ VDD VSS _252_ OA21x2_ASAP7_75t_R
X_530_ dpath.a_lt_b$in0\[13\] _233_ _249_ _159_ _252_ VDD
+ VSS _253_ AO221x1_ASAP7_75t_R
X_531_ _157_ _249_ _253_ VDD VSS _092_ AO21x1_ASAP7_75t_R
X_532_ _066_ _238_ VDD VSS _254_ AND2x2_ASAP7_75t_R
X_533_ _043_ _065_ _254_ VDD VSS _255_ OAI21x1_ASAP7_75t_R
X_534_ _237_ net40 _255_ VDD VSS _256_ AO21x1_ASAP7_75t_R
X_535_ net55 net21 _238_ VDD VSS _257_ OA21x2_ASAP7_75t_R
X_536_ dpath.a_lt_b$in0\[12\] _233_ _257_ VDD VSS _258_ AO21x1_ASAP7_75t_R
X_537_ _256_ _258_ VDD VSS _093_ AND2x2_ASAP7_75t_R
X_538_ _066_ net20 _233_ VDD VSS _259_ OR3x1_ASAP7_75t_R
X_539_ dpath.a_lt_b$in0\[11\] _238_ _259_ VDD VSS _260_ OAI21x1_ASAP7_75t_R
X_540_ _068_ _051_ _260_ VDD VSS _261_ OR3x1_ASAP7_75t_R
X_541_ _261_ VDD VSS _262_ INVx1_ASAP7_75t_R
X_542_ _161_ _164_ _262_ _166_ VDD VSS _263_ OA211x2_ASAP7_75t_R
X_543_ _068_ _160_ _260_ VDD VSS _264_ OR3x1_ASAP7_75t_R
X_544_ _161_ _164_ _264_ VDD VSS _265_ NOR3x1_ASAP7_75t_R
X_545_ _049_ _065_ _254_ VDD VSS _266_ OA21x2_ASAP7_75t_R
X_546_ _260_ _266_ _264_ _166_ VDD VSS _267_ OAI22x1_ASAP7_75t_R
X_547_ _263_ _265_ _267_ VDD VSS _094_ OR3x1_ASAP7_75t_R
X_548_ _169_ _170_ _029_ VDD VSS _268_ OA21x2_ASAP7_75t_R
X_549_ _057_ VDD VSS _269_ INVx1_ASAP7_75t_R
X_550_ _066_ net19 _239_ VDD VSS _270_ OA21x2_ASAP7_75t_R
X_551_ _059_ _269_ _270_ VDD VSS _271_ AND3x1_ASAP7_75t_R
X_552_ _057_ _168_ VDD VSS _272_ AND2x2_ASAP7_75t_R
X_553_ _059_ _269_ _060_ VDD VSS _273_ AND3x1_ASAP7_75t_R
X_554_ _172_ _057_ _171_ _272_ _273_ VDD VSS _274_ AO221x1_ASAP7_75t_R
X_555_ _241_ net19 VDD VSS _275_ AND2x2_ASAP7_75t_R
X_556_ _203_ _244_ net55 VDD VSS _276_ AND3x1_ASAP7_75t_R
X_557_ _275_ _276_ _238_ VDD VSS _277_ OA21x2_ASAP7_75t_R
X_558_ dpath.a_lt_b$in0\[10\] _233_ _277_ VDD VSS _278_ AO21x1_ASAP7_75t_R
X_559_ _268_ _271_ _274_ _270_ _278_ VDD VSS _095_ AO221x1_ASAP7_75t_R
X_560_ net55 net18 VDD VSS _279_ OR2x2_ASAP7_75t_R
X_561_ _206_ _244_ net55 VDD VSS _280_ AND3x1_ASAP7_75t_R
X_562_ _241_ net18 net56 _002_ _280_ VDD VSS _281_ AO221x1_ASAP7_75t_R
X_563_ _010_ _233_ VDD VSS _282_ NAND2x1_ASAP7_75t_R
X_564_ net52 _239_ _279_ _281_ _282_ VDD VSS _096_ AO32x1_ASAP7_75t_R
X_565_ _066_ net17 _238_ VDD VSS _283_ OAI21x1_ASAP7_75t_R
X_566_ _009_ _238_ _283_ VDD VSS _284_ OA21x2_ASAP7_75t_R
X_567_ _028_ _065_ _254_ VDD VSS _285_ OA21x2_ASAP7_75t_R
X_568_ _284_ _285_ VDD VSS _286_ NOR2x1_ASAP7_75t_R
X_569_ _284_ VDD VSS _287_ INVx1_ASAP7_75t_R
X_570_ _030_ _237_ _176_ _287_ VDD VSS _288_ AND4x1_ASAP7_75t_R
X_571_ _030_ _068_ _284_ VDD VSS _289_ OR3x1_ASAP7_75t_R
X_572_ _176_ _289_ VDD VSS _290_ NOR2x1_ASAP7_75t_R
X_573_ _286_ _288_ _290_ VDD VSS _097_ OR3x1_ASAP7_75t_R
X_574_ _066_ net16 _233_ VDD VSS _291_ OR3x1_ASAP7_75t_R
X_575_ dpath.a_lt_b$in0\[7\] _238_ _291_ VDD VSS _292_ OAI21x1_ASAP7_75t_R
X_576_ _068_ _292_ VDD VSS _293_ NOR2x1_ASAP7_75t_R
X_577_ _031_ _065_ _254_ VDD VSS _294_ OA21x2_ASAP7_75t_R
X_578_ _292_ _294_ VDD VSS _295_ NOR2x1_ASAP7_75t_R
X_579_ net50 _293_ _295_ VDD VSS _098_ AO21x1_ASAP7_75t_R
X_580_ _215_ _244_ net49 _237_ _241_ VDD VSS _296_ AO221x1_ASAP7_75t_R
X_581_ _066_ net15 _238_ _296_ VDD VSS _297_ OA211x2_ASAP7_75t_R
X_582_ dpath.a_lt_b$in0\[6\] _233_ _297_ VDD VSS _099_ AO21x1_ASAP7_75t_R
X_583_ _034_ _065_ _254_ VDD VSS _298_ OAI21x1_ASAP7_75t_R
X_584_ _237_ net48 _298_ VDD VSS _299_ AO21x1_ASAP7_75t_R
X_585_ _066_ net14 _238_ VDD VSS _300_ OA21x2_ASAP7_75t_R
X_586_ dpath.a_lt_b$in0\[5\] _233_ _300_ VDD VSS _301_ AO21x1_ASAP7_75t_R
X_587_ _299_ _301_ VDD VSS _100_ AND2x2_ASAP7_75t_R
X_588_ _221_ _244_ net47 _237_ _241_ VDD VSS _302_ AO221x1_ASAP7_75t_R
X_589_ _066_ net13 _238_ _302_ VDD VSS _303_ OA211x2_ASAP7_75t_R
X_590_ dpath.a_lt_b$in0\[4\] _233_ _303_ VDD VSS _101_ AO21x1_ASAP7_75t_R
X_591_ _224_ _244_ net46 _237_ _241_ VDD VSS _304_ AO221x1_ASAP7_75t_R
X_592_ _066_ net11 _238_ _304_ VDD VSS _305_ OA211x2_ASAP7_75t_R
X_593_ dpath.a_lt_b$in0\[3\] _233_ _305_ VDD VSS _102_ AO21x1_ASAP7_75t_R
X_594_ _227_ _244_ net45 _237_ VDD VSS _306_ AO22x1_ASAP7_75t_R
X_595_ net55 net10 VDD VSS _307_ OR2x2_ASAP7_75t_R
X_596_ _241_ _306_ _307_ _238_ VDD VSS _308_ OA211x2_ASAP7_75t_R
X_597_ dpath.a_lt_b$in0\[2\] _233_ _308_ VDD VSS _103_ AO21x1_ASAP7_75t_R
X_598_ dpath.a_lt_b$in1\[1\] _244_ net44 _237_ _241_ VDD VSS
+ _309_ AO221x1_ASAP7_75t_R
X_599_ net55 net9 _238_ _309_ VDD VSS _310_ OA211x2_ASAP7_75t_R
X_600_ dpath.a_lt_b$in0\[1\] _233_ _310_ VDD VSS _104_ AO21x1_ASAP7_75t_R
X_601_ dpath.a_lt_b$in1\[0\] _244_ net37 _237_ _241_ VDD VSS
+ _311_ AO221x1_ASAP7_75t_R
X_602_ net55 net8 _238_ _311_ VDD VSS _312_ OA211x2_ASAP7_75t_R
X_603_ dpath.a_lt_b$in0\[0\] _233_ _312_ VDD VSS _105_ AO21x1_ASAP7_75t_R
X_604_ net33 VDD VSS _313_ INVx1_ASAP7_75t_R
X_605_ _017_ _238_ VDD VSS net53 NOR2x1_ASAP7_75t_R
X_606_ net36 _313_ net35 net53 net34 VDD VSS _073_ AO221x1_ASAP7_75t_R
X_607_ _031_ _028_ _058_ _046_ VDD VSS _314_ AND4x1_ASAP7_75t_R
X_608_ _055_ _049_ _043_ _022_ _314_ VDD VSS _315_ AND5x1_ASAP7_75t_R
X_609_ _052_ _069_ _021_ _025_ VDD VSS _316_ AND4x1_ASAP7_75t_R
X_610_ _061_ _040_ _037_ _034_ _316_ VDD VSS _317_ AND5x1_ASAP7_75t_R
X_611_ _315_ _317_ VDD VSS _318_ NAND2x1_ASAP7_75t_R
X_612_ _002_ _184_ _318_ VDD VSS _319_ OR3x1_ASAP7_75t_R
X_613_ net35 _233_ _319_ _017_ net34 VDD VSS _074_ AOI221x1_ASAP7_75t_R
X_614_ net36 net33 _318_ _136_ VDD VSS _320_ AOI22x1_ASAP7_75t_R
X_615_ _141_ _320_ net34 VDD VSS _075_ AOI21x1_ASAP7_75t_R
X_616_ dpath.a_lt_b$in0\[15\] net56 VDD VSS _321_ AND2x2_ASAP7_75t_R
X_617_ _052_ VDD VSS _322_ INVx1_ASAP7_75t_R
X_618_ _322_ net56 _141_ VDD VSS _323_ AND3x1_ASAP7_75t_R
X_619_ net36 net7 _185_ _321_ _323_ VDD VSS _106_ AO221x1_ASAP7_75t_R
X_620_ net55 net25 VDD VSS _324_ OR2x2_ASAP7_75t_R
X_621_ _322_ _244_ net55 VDD VSS _325_ AND3x1_ASAP7_75t_R
X_622_ _002_ net56 net25 _241_ _325_ VDD VSS _326_ AO221x1_ASAP7_75t_R
X_623_ _001_ _233_ VDD VSS _327_ NAND2x1_ASAP7_75t_R
X_624_ net43 _239_ _324_ _326_ _327_ VDD VSS _107_ AO32x1_ASAP7_75t_R
X_625_ _018_ dpath.a_lt_b$in1\[1\] _019_ _000_ net44 VDD VSS
+ FAx1_ASAP7_75t_R
X_626_ _022_ dpath.a_lt_b$in0\[13\] _023_ _024_ VDD VSS HAxp5_ASAP7_75t_R
X_627_ _025_ dpath.a_lt_b$in0\[6\] _026_ _027_ VDD VSS HAxp5_ASAP7_75t_R
X_628_ _028_ dpath.a_lt_b$in0\[8\] _029_ _030_ VDD VSS HAxp5_ASAP7_75t_R
X_629_ _031_ dpath.a_lt_b$in0\[7\] _032_ _033_ VDD VSS HAxp5_ASAP7_75t_R
X_630_ _034_ dpath.a_lt_b$in0\[5\] _035_ _036_ VDD VSS HAxp5_ASAP7_75t_R
X_631_ _037_ dpath.a_lt_b$in0\[4\] _038_ _039_ VDD VSS HAxp5_ASAP7_75t_R
X_632_ _040_ dpath.a_lt_b$in0\[3\] _041_ _042_ VDD VSS HAxp5_ASAP7_75t_R
X_633_ _043_ dpath.a_lt_b$in0\[12\] _044_ _045_ VDD VSS HAxp5_ASAP7_75t_R
X_634_ _046_ dpath.a_lt_b$in0\[14\] _047_ _048_ VDD VSS HAxp5_ASAP7_75t_R
X_635_ _049_ dpath.a_lt_b$in0\[11\] _050_ _051_ VDD VSS HAxp5_ASAP7_75t_R
X_636_ _052_ dpath.a_lt_b$in0\[15\] _053_ _054_ VDD VSS HAxp5_ASAP7_75t_R
X_637_ _055_ dpath.a_lt_b$in0\[10\] _056_ _057_ VDD VSS HAxp5_ASAP7_75t_R
X_638_ _058_ dpath.a_lt_b$in0\[9\] _059_ _060_ VDD VSS HAxp5_ASAP7_75t_R
X_639_ _061_ dpath.a_lt_b$in0\[2\] _062_ _063_ VDD VSS HAxp5_ASAP7_75t_R
X_640_ _064_ ctrl$a_mux_sel\[1\] _065_ _066_ VDD VSS HAxp5_ASAP7_75t_R
X_641_ ctrl$a_mux_sel\[0\] _067_ _068_ _328_ VDD VSS HAxp5_ASAP7_75t_R
X_642_ _069_ dpath.a_lt_b$in0\[0\] _329_ net37 VDD VSS HAxp5_ASAP7_75t_R
X_643_ dpath.a_lt_b$in1\[0\] _070_ _020_ _330_ VDD VSS HAxp5_ASAP7_75t_R
X_644_ _021_ dpath.a_lt_b$in0\[1\] _071_ _072_ VDD VSS HAxp5_ASAP7_75t_R
Xctrl.state.out\[0\]$_DFF_P_ clknet_2_0__leaf_clk _073_ _016_
+ VDD VSS DFFHQNx1_ASAP7_75t_R
Xctrl.state.out\[1\]$_DFF_P_ clknet_2_0__leaf_clk _074_ _017_
+ VDD VSS DFFHQNx1_ASAP7_75t_R
Xctrl.state.out\[2\]$_DFF_P_ clknet_2_0__leaf_clk _075_ _002_
+ VDD VSS DFFHQNx1_ASAP7_75t_R
Xdpath.a_reg.out\[0\]$_DFFE_PP_ clknet_2_2__leaf_clk _105_
+ _070_ VDD VSS DFFHQNx1_ASAP7_75t_R
Xdpath.a_reg.out\[10\]$_DFFE_PP_ clknet_2_1__leaf_clk _095_
+ _011_ VDD VSS DFFHQNx1_ASAP7_75t_R
Xdpath.a_reg.out\[11\]$_DFFE_PP_ clknet_2_1__leaf_clk _094_
+ _012_ VDD VSS DFFHQNx1_ASAP7_75t_R
Xdpath.a_reg.out\[12\]$_DFFE_PP_ clknet_2_2__leaf_clk _093_
+ _013_ VDD VSS DFFHQNx1_ASAP7_75t_R
Xdpath.a_reg.out\[13\]$_DFFE_PP_ clknet_2_3__leaf_clk _092_
+ _014_ VDD VSS DFFHQNx1_ASAP7_75t_R
Xdpath.a_reg.out\[14\]$_DFFE_PP_ clknet_2_0__leaf_clk _091_
+ _015_ VDD VSS DFFHQNx1_ASAP7_75t_R
Xdpath.a_reg.out\[15\]$_DFFE_PP_ clknet_2_2__leaf_clk _107_
+ _001_ VDD VSS DFFHQNx1_ASAP7_75t_R
Xdpath.a_reg.out\[1\]$_DFFE_PP_ clknet_2_2__leaf_clk _104_
+ _019_ VDD VSS DFFHQNx1_ASAP7_75t_R
Xdpath.a_reg.out\[2\]$_DFFE_PP_ clknet_2_3__leaf_clk _103_
+ _003_ VDD VSS DFFHQNx1_ASAP7_75t_R
Xdpath.a_reg.out\[3\]$_DFFE_PP_ clknet_2_3__leaf_clk _102_
+ _004_ VDD VSS DFFHQNx1_ASAP7_75t_R
Xdpath.a_reg.out\[4\]$_DFFE_PP_ clknet_2_3__leaf_clk _101_
+ _005_ VDD VSS DFFHQNx1_ASAP7_75t_R
Xdpath.a_reg.out\[5\]$_DFFE_PP_ clknet_2_3__leaf_clk _100_
+ _006_ VDD VSS DFFHQNx1_ASAP7_75t_R
Xdpath.a_reg.out\[6\]$_DFFE_PP_ clknet_2_3__leaf_clk _099_
+ _007_ VDD VSS DFFHQNx1_ASAP7_75t_R
Xdpath.a_reg.out\[7\]$_DFFE_PP_ clknet_2_1__leaf_clk _098_
+ _008_ VDD VSS DFFHQNx1_ASAP7_75t_R
Xdpath.a_reg.out\[8\]$_DFFE_PP_ clknet_2_1__leaf_clk _097_
+ _009_ VDD VSS DFFHQNx1_ASAP7_75t_R
Xdpath.a_reg.out\[9\]$_DFFE_PP_ clknet_2_0__leaf_clk _096_
+ _010_ VDD VSS DFFHQNx1_ASAP7_75t_R
Xdpath.b_reg.out\[0\]$_DFFE_PP_ clknet_2_2__leaf_clk _090_
+ _069_ VDD VSS DFFHQNx1_ASAP7_75t_R
Xdpath.b_reg.out\[10\]$_DFFE_PP_ clknet_2_1__leaf_clk _080_
+ _055_ VDD VSS DFFHQNx1_ASAP7_75t_R
Xdpath.b_reg.out\[11\]$_DFFE_PP_ clknet_2_0__leaf_clk _079_
+ _049_ VDD VSS DFFHQNx1_ASAP7_75t_R
Xdpath.b_reg.out\[12\]$_DFFE_PP_ clknet_2_0__leaf_clk _078_
+ _043_ VDD VSS DFFHQNx1_ASAP7_75t_R
Xdpath.b_reg.out\[13\]$_DFFE_PP_ clknet_2_2__leaf_clk _077_
+ _022_ VDD VSS DFFHQNx1_ASAP7_75t_R
Xdpath.b_reg.out\[14\]$_DFFE_PP_ clknet_2_0__leaf_clk _076_
+ _046_ VDD VSS DFFHQNx1_ASAP7_75t_R
Xdpath.b_reg.out\[15\]$_DFFE_PP_ clknet_2_2__leaf_clk _106_
+ _052_ VDD VSS DFFHQNx1_ASAP7_75t_R
Xdpath.b_reg.out\[1\]$_DFFE_PP_ clknet_2_2__leaf_clk _089_
+ _021_ VDD VSS DFFHQNx1_ASAP7_75t_R
Xdpath.b_reg.out\[2\]$_DFFE_PP_ clknet_2_2__leaf_clk _088_
+ _061_ VDD VSS DFFHQNx1_ASAP7_75t_R
Xdpath.b_reg.out\[3\]$_DFFE_PP_ clknet_2_3__leaf_clk _087_
+ _040_ VDD VSS DFFHQNx1_ASAP7_75t_R
Xdpath.b_reg.out\[4\]$_DFFE_PP_ clknet_2_3__leaf_clk _086_
+ _037_ VDD VSS DFFHQNx1_ASAP7_75t_R
Xdpath.b_reg.out\[5\]$_DFFE_PP_ clknet_2_2__leaf_clk _085_
+ _034_ VDD VSS DFFHQNx1_ASAP7_75t_R
Xdpath.b_reg.out\[6\]$_DFFE_PP_ clknet_2_3__leaf_clk _084_
+ _025_ VDD VSS DFFHQNx1_ASAP7_75t_R
Xdpath.b_reg.out\[7\]$_DFFE_PP_ clknet_2_1__leaf_clk _083_
+ _031_ VDD VSS DFFHQNx1_ASAP7_75t_R
Xdpath.b_reg.out\[8\]$_DFFE_PP_ clknet_2_1__leaf_clk _082_
+ _028_ VDD VSS DFFHQNx1_ASAP7_75t_R
Xdpath.b_reg.out\[9\]$_DFFE_PP_ clknet_2_0__leaf_clk _081_
+ _058_ VDD VSS DFFHQNx1_ASAP7_75t_R
XPHY_EDGE_ROW_0_Right_0 VDD VSS TAPCELL_ASAP7_75t_R
XPHY_EDGE_ROW_1_Right_1 VDD VSS TAPCELL_ASAP7_75t_R
XPHY_EDGE_ROW_2_Right_2 VDD VSS TAPCELL_ASAP7_75t_R
XPHY_EDGE_ROW_3_Right_3 VDD VSS TAPCELL_ASAP7_75t_R
XPHY_EDGE_ROW_4_Right_4 VDD VSS TAPCELL_ASAP7_75t_R
XPHY_EDGE_ROW_5_Right_5 VDD VSS TAPCELL_ASAP7_75t_R
XPHY_EDGE_ROW_6_Right_6 VDD VSS TAPCELL_ASAP7_75t_R
XPHY_EDGE_ROW_7_Right_7 VDD VSS TAPCELL_ASAP7_75t_R
XPHY_EDGE_ROW_8_Right_8 VDD VSS TAPCELL_ASAP7_75t_R
XPHY_EDGE_ROW_9_Right_9 VDD VSS TAPCELL_ASAP7_75t_R
XPHY_EDGE_ROW_10_Right_10 VDD VSS TAPCELL_ASAP7_75t_R
XPHY_EDGE_ROW_11_Right_11 VDD VSS TAPCELL_ASAP7_75t_R
XPHY_EDGE_ROW_12_Right_12 VDD VSS TAPCELL_ASAP7_75t_R
XPHY_EDGE_ROW_13_Right_13 VDD VSS TAPCELL_ASAP7_75t_R
XPHY_EDGE_ROW_14_Right_14 VDD VSS TAPCELL_ASAP7_75t_R
XPHY_EDGE_ROW_15_Right_15 VDD VSS TAPCELL_ASAP7_75t_R
XPHY_EDGE_ROW_16_Right_16 VDD VSS TAPCELL_ASAP7_75t_R
XPHY_EDGE_ROW_17_Right_17 VDD VSS TAPCELL_ASAP7_75t_R
XPHY_EDGE_ROW_18_Right_18 VDD VSS TAPCELL_ASAP7_75t_R
XPHY_EDGE_ROW_19_Right_19 VDD VSS TAPCELL_ASAP7_75t_R
XPHY_EDGE_ROW_20_Right_20 VDD VSS TAPCELL_ASAP7_75t_R
XPHY_EDGE_ROW_21_Right_21 VDD VSS TAPCELL_ASAP7_75t_R
XPHY_EDGE_ROW_22_Right_22 VDD VSS TAPCELL_ASAP7_75t_R
XPHY_EDGE_ROW_23_Right_23 VDD VSS TAPCELL_ASAP7_75t_R
XPHY_EDGE_ROW_24_Right_24 VDD VSS TAPCELL_ASAP7_75t_R
XPHY_EDGE_ROW_25_Right_25 VDD VSS TAPCELL_ASAP7_75t_R
XPHY_EDGE_ROW_26_Right_26 VDD VSS TAPCELL_ASAP7_75t_R
XPHY_EDGE_ROW_27_Right_27 VDD VSS TAPCELL_ASAP7_75t_R
XPHY_EDGE_ROW_28_Right_28 VDD VSS TAPCELL_ASAP7_75t_R
XPHY_EDGE_ROW_29_Right_29 VDD VSS TAPCELL_ASAP7_75t_R
XPHY_EDGE_ROW_30_Right_30 VDD VSS TAPCELL_ASAP7_75t_R
XPHY_EDGE_ROW_31_Right_31 VDD VSS TAPCELL_ASAP7_75t_R
XPHY_EDGE_ROW_32_Right_32 VDD VSS TAPCELL_ASAP7_75t_R
XPHY_EDGE_ROW_33_Right_33 VDD VSS TAPCELL_ASAP7_75t_R
XPHY_EDGE_ROW_34_Right_34 VDD VSS TAPCELL_ASAP7_75t_R
XPHY_EDGE_ROW_35_Right_35 VDD VSS TAPCELL_ASAP7_75t_R
XPHY_EDGE_ROW_36_Right_36 VDD VSS TAPCELL_ASAP7_75t_R
XPHY_EDGE_ROW_37_Right_37 VDD VSS TAPCELL_ASAP7_75t_R
XPHY_EDGE_ROW_38_Right_38 VDD VSS TAPCELL_ASAP7_75t_R
XPHY_EDGE_ROW_39_Right_39 VDD VSS TAPCELL_ASAP7_75t_R
XPHY_EDGE_ROW_40_Right_40 VDD VSS TAPCELL_ASAP7_75t_R
XPHY_EDGE_ROW_41_Right_41 VDD VSS TAPCELL_ASAP7_75t_R
XPHY_EDGE_ROW_42_Right_42 VDD VSS TAPCELL_ASAP7_75t_R
XPHY_EDGE_ROW_43_Right_43 VDD VSS TAPCELL_ASAP7_75t_R
XPHY_EDGE_ROW_44_Right_44 VDD VSS TAPCELL_ASAP7_75t_R
XPHY_EDGE_ROW_45_Right_45 VDD VSS TAPCELL_ASAP7_75t_R
XPHY_EDGE_ROW_46_Right_46 VDD VSS TAPCELL_ASAP7_75t_R
XPHY_EDGE_ROW_47_Right_47 VDD VSS TAPCELL_ASAP7_75t_R
XPHY_EDGE_ROW_48_Right_48 VDD VSS TAPCELL_ASAP7_75t_R
XPHY_EDGE_ROW_49_Right_49 VDD VSS TAPCELL_ASAP7_75t_R
XPHY_EDGE_ROW_50_Right_50 VDD VSS TAPCELL_ASAP7_75t_R
XPHY_EDGE_ROW_51_Right_51 VDD VSS TAPCELL_ASAP7_75t_R
XPHY_EDGE_ROW_0_Left_52 VDD VSS TAPCELL_ASAP7_75t_R
XPHY_EDGE_ROW_1_Left_53 VDD VSS TAPCELL_ASAP7_75t_R
XPHY_EDGE_ROW_2_Left_54 VDD VSS TAPCELL_ASAP7_75t_R
XPHY_EDGE_ROW_3_Left_55 VDD VSS TAPCELL_ASAP7_75t_R
XPHY_EDGE_ROW_4_Left_56 VDD VSS TAPCELL_ASAP7_75t_R
XPHY_EDGE_ROW_5_Left_57 VDD VSS TAPCELL_ASAP7_75t_R
XPHY_EDGE_ROW_6_Left_58 VDD VSS TAPCELL_ASAP7_75t_R
XPHY_EDGE_ROW_7_Left_59 VDD VSS TAPCELL_ASAP7_75t_R
XPHY_EDGE_ROW_8_Left_60 VDD VSS TAPCELL_ASAP7_75t_R
XPHY_EDGE_ROW_9_Left_61 VDD VSS TAPCELL_ASAP7_75t_R
XPHY_EDGE_ROW_10_Left_62 VDD VSS TAPCELL_ASAP7_75t_R
XPHY_EDGE_ROW_11_Left_63 VDD VSS TAPCELL_ASAP7_75t_R
XPHY_EDGE_ROW_12_Left_64 VDD VSS TAPCELL_ASAP7_75t_R
XPHY_EDGE_ROW_13_Left_65 VDD VSS TAPCELL_ASAP7_75t_R
XPHY_EDGE_ROW_14_Left_66 VDD VSS TAPCELL_ASAP7_75t_R
XPHY_EDGE_ROW_15_Left_67 VDD VSS TAPCELL_ASAP7_75t_R
XPHY_EDGE_ROW_16_Left_68 VDD VSS TAPCELL_ASAP7_75t_R
XPHY_EDGE_ROW_17_Left_69 VDD VSS TAPCELL_ASAP7_75t_R
XPHY_EDGE_ROW_18_Left_70 VDD VSS TAPCELL_ASAP7_75t_R
XPHY_EDGE_ROW_19_Left_71 VDD VSS TAPCELL_ASAP7_75t_R
XPHY_EDGE_ROW_20_Left_72 VDD VSS TAPCELL_ASAP7_75t_R
XPHY_EDGE_ROW_21_Left_73 VDD VSS TAPCELL_ASAP7_75t_R
XPHY_EDGE_ROW_22_Left_74 VDD VSS TAPCELL_ASAP7_75t_R
XPHY_EDGE_ROW_23_Left_75 VDD VSS TAPCELL_ASAP7_75t_R
XPHY_EDGE_ROW_24_Left_76 VDD VSS TAPCELL_ASAP7_75t_R
XPHY_EDGE_ROW_25_Left_77 VDD VSS TAPCELL_ASAP7_75t_R
XPHY_EDGE_ROW_26_Left_78 VDD VSS TAPCELL_ASAP7_75t_R
XPHY_EDGE_ROW_27_Left_79 VDD VSS TAPCELL_ASAP7_75t_R
XPHY_EDGE_ROW_28_Left_80 VDD VSS TAPCELL_ASAP7_75t_R
XPHY_EDGE_ROW_29_Left_81 VDD VSS TAPCELL_ASAP7_75t_R
XPHY_EDGE_ROW_30_Left_82 VDD VSS TAPCELL_ASAP7_75t_R
XPHY_EDGE_ROW_31_Left_83 VDD VSS TAPCELL_ASAP7_75t_R
XPHY_EDGE_ROW_32_Left_84 VDD VSS TAPCELL_ASAP7_75t_R
XPHY_EDGE_ROW_33_Left_85 VDD VSS TAPCELL_ASAP7_75t_R
XPHY_EDGE_ROW_34_Left_86 VDD VSS TAPCELL_ASAP7_75t_R
XPHY_EDGE_ROW_35_Left_87 VDD VSS TAPCELL_ASAP7_75t_R
XPHY_EDGE_ROW_36_Left_88 VDD VSS TAPCELL_ASAP7_75t_R
XPHY_EDGE_ROW_37_Left_89 VDD VSS TAPCELL_ASAP7_75t_R
XPHY_EDGE_ROW_38_Left_90 VDD VSS TAPCELL_ASAP7_75t_R
XPHY_EDGE_ROW_39_Left_91 VDD VSS TAPCELL_ASAP7_75t_R
XPHY_EDGE_ROW_40_Left_92 VDD VSS TAPCELL_ASAP7_75t_R
XPHY_EDGE_ROW_41_Left_93 VDD VSS TAPCELL_ASAP7_75t_R
XPHY_EDGE_ROW_42_Left_94 VDD VSS TAPCELL_ASAP7_75t_R
XPHY_EDGE_ROW_43_Left_95 VDD VSS TAPCELL_ASAP7_75t_R
XPHY_EDGE_ROW_44_Left_96 VDD VSS TAPCELL_ASAP7_75t_R
XPHY_EDGE_ROW_45_Left_97 VDD VSS TAPCELL_ASAP7_75t_R
XPHY_EDGE_ROW_46_Left_98 VDD VSS TAPCELL_ASAP7_75t_R
XPHY_EDGE_ROW_47_Left_99 VDD VSS TAPCELL_ASAP7_75t_R
XPHY_EDGE_ROW_48_Left_100 VDD VSS TAPCELL_ASAP7_75t_R
XPHY_EDGE_ROW_49_Left_101 VDD VSS TAPCELL_ASAP7_75t_R
XPHY_EDGE_ROW_50_Left_102 VDD VSS TAPCELL_ASAP7_75t_R
XPHY_EDGE_ROW_51_Left_103 VDD VSS TAPCELL_ASAP7_75t_R
Xinput18 req_msg[25] VDD VSS net18 BUFx2_ASAP7_75t_R
Xinput19 req_msg[26] VDD VSS net19 BUFx2_ASAP7_75t_R
Xinput20 req_msg[27] VDD VSS net20 BUFx2_ASAP7_75t_R
Xinput21 req_msg[28] VDD VSS net21 BUFx2_ASAP7_75t_R
Xinput22 req_msg[29] VDD VSS net22 BUFx2_ASAP7_75t_R
Xinput23 req_msg[2] VDD VSS net23 BUFx2_ASAP7_75t_R
Xinput24 req_msg[30] VDD VSS net24 BUFx2_ASAP7_75t_R
Xinput25 req_msg[31] VDD VSS net25 BUFx2_ASAP7_75t_R
Xinput26 req_msg[3] VDD VSS net26 BUFx2_ASAP7_75t_R
Xinput27 req_msg[4] VDD VSS net27 BUFx2_ASAP7_75t_R
Xinput28 req_msg[5] VDD VSS net28 BUFx2_ASAP7_75t_R
Xinput29 req_msg[6] VDD VSS net29 BUFx2_ASAP7_75t_R
Xinput30 req_msg[7] VDD VSS net30 BUFx2_ASAP7_75t_R
Xinput31 req_msg[8] VDD VSS net31 BUFx2_ASAP7_75t_R
Xinput32 req_msg[9] VDD VSS net32 BUFx2_ASAP7_75t_R
Xinput33 req_val VDD VSS net33 BUFx2_ASAP7_75t_R
Xinput34 reset VDD VSS net34 BUFx2_ASAP7_75t_R
Xinput35 resp_rdy VDD VSS net35 BUFx2_ASAP7_75t_R
Xoutput36 net36 VDD VSS req_rdy BUFx2_ASAP7_75t_R
Xoutput37 net37 VDD VSS resp_msg[0] BUFx2_ASAP7_75t_R
Xoutput38 net38 VDD VSS resp_msg[10] BUFx2_ASAP7_75t_R
Xoutput39 net39 VDD VSS resp_msg[11] BUFx2_ASAP7_75t_R
Xoutput40 net40 VDD VSS resp_msg[12] BUFx2_ASAP7_75t_R
Xoutput41 net41 VDD VSS resp_msg[13] BUFx2_ASAP7_75t_R
Xoutput42 net42 VDD VSS resp_msg[14] BUFx2_ASAP7_75t_R
Xoutput43 net43 VDD VSS resp_msg[15] BUFx2_ASAP7_75t_R
Xoutput44 net44 VDD VSS resp_msg[1] BUFx2_ASAP7_75t_R
Xoutput45 net45 VDD VSS resp_msg[2] BUFx2_ASAP7_75t_R
Xoutput46 net46 VDD VSS resp_msg[3] BUFx2_ASAP7_75t_R
Xoutput47 net47 VDD VSS resp_msg[4] BUFx2_ASAP7_75t_R
Xoutput48 net48 VDD VSS resp_msg[5] BUFx2_ASAP7_75t_R
Xoutput49 net49 VDD VSS resp_msg[6] BUFx2_ASAP7_75t_R
Xoutput50 net50 VDD VSS resp_msg[7] BUFx2_ASAP7_75t_R
Xoutput51 net51 VDD VSS resp_msg[8] BUFx2_ASAP7_75t_R
Xoutput52 net52 VDD VSS resp_msg[9] BUFx2_ASAP7_75t_R
Xoutput53 net53 VDD VSS resp_val BUFx2_ASAP7_75t_R
Xplace56 _016_ VDD VSS net56 BUFx3_ASAP7_75t_R
Xplace55 _066_ VDD VSS net55 BUFx3_ASAP7_75t_R
Xclkbuf_0_clk clk VDD VSS clknet_0_clk BUFx4_ASAP7_75t_R
Xclkbuf_2_0__f_clk clknet_0_clk VDD VSS clknet_2_0__leaf_clk
+ BUFx4_ASAP7_75t_R
Xclkbuf_2_1__f_clk clknet_0_clk VDD VSS clknet_2_1__leaf_clk
+ BUFx4_ASAP7_75t_R
Xclkbuf_2_2__f_clk clknet_0_clk VDD VSS clknet_2_2__leaf_clk
+ BUFx4_ASAP7_75t_R
Xclkbuf_2_3__f_clk clknet_0_clk VDD VSS clknet_2_3__leaf_clk
+ BUFx4_ASAP7_75t_R
Xclkload0 clknet_2_0__leaf_clk VDD VSS _unconnected_0 BUFx2_ASAP7_75t_R
Xclkload1 clknet_2_1__leaf_clk VDD VSS _unconnected_1 BUFx12_ASAP7_75t_R
Xclkload2 clknet_2_3__leaf_clk VDD VSS _unconnected_2 BUFx2_ASAP7_75t_R
.ENDS gcd
