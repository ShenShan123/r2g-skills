* References derived from independently published official xACT PEX; no tested layout extraction used.
* BSD 3-Clause License
*
* Copyright 2022 Lawrence T. Clark, Vinay Vashishtha, or Arizona State
* University
*
* Redistribution and use in source and binary forms, with or without
* modification, are permitted provided that the following conditions are met:
*
* 1. Redistributions of source code must retain the above copyright notice,
* this list of conditions and the following disclaimer.
*
* 2. Redistributions in binary form must reproduce the above copyright
* notice, this list of conditions and the following disclaimer in the
* documentation and/or other materials provided with the distribution.
*
* 3. Neither the name of the copyright holder nor the names of its
* contributors may be used to endorse or promote products derived from this
* software without specific prior written permission.
*
* THIS SOFTWARE IS PROVIDED BY THE COPYRIGHT HOLDERS AND CONTRIBUTORS "AS IS"
* AND ANY EXPRESS OR IMPLIED WARRANTIES, INCLUDING, BUT NOT LIMITED TO, THE
* IMPLIED WARRANTIES OF MERCHANTABILITY AND FITNESS FOR A PARTICULAR PURPOSE
* ARE DISCLAIMED. IN NO EVENT SHALL THE COPYRIGHT HOLDER OR CONTRIBUTORS BE
* LIABLE FOR ANY DIRECT, INDIRECT, INCIDENTAL, SPECIAL, EXEMPLARY, OR
* CONSEQUENTIAL DAMAGES (INCLUDING, BUT NOT LIMITED TO, PROCUREMENT OF
* SUBSTITUTE GOODS OR SERVICES; LOSS OF USE, DATA, OR PROFITS; OR BUSINESS
* INTERRUPTION) HOWEVER CAUSED AND ON ANY THEORY OF LIABILITY, WHETHER IN
* CONTRACT, STRICT LIABILITY, OR TORT (INCLUDING NEGLIGENCE OR OTHERWISE)
* ARISING IN ANY WAY OUT OF THE USE OF THIS SOFTWARE, EVEN IF ADVISED OF THE
* POSSIBILITY OF SUCH DAMAGE.

.SUBCKT A2O1A1Ixp33_ASAP7_75t_R A1 A2 B C VDD VSS Y
MM7 net06 B VSS VSS nmos_rvt w=81.0n l=20n nfin=3
MM2 Y C net06 VSS nmos_rvt w=81.0n l=20n nfin=3
MM1 net015 A2 VSS VSS nmos_rvt w=81.0n l=20n nfin=3
MM0 net06 A1 net015 VSS nmos_rvt w=81.0n l=20n nfin=3
MM6 Y C VDD VDD pmos_rvt w=54.0n l=20n nfin=2
MM5 Y B net2 VDD pmos_rvt w=81.0n l=20n nfin=3
MM4 net2 A2 VDD VDD pmos_rvt w=81.0n l=20n nfin=3
MM3 net2 A1 VDD VDD pmos_rvt w=81.0n l=20n nfin=3
.ENDS

.SUBCKT A2O1A1O1Ixp25_ASAP7_75t_R A1 A2 B C D VDD VSS Y
MM5 net4 A1 VDD VDD pmos_rvt w=81.0n l=20n nfin=3
MM8 net15 C VDD VDD pmos_rvt w=81.0n l=20n nfin=3
MM6 net4 A2 VDD VDD pmos_rvt w=81.0n l=20n nfin=3
MM9 Y D net15 VDD pmos_rvt w=81.0n l=20n nfin=3
MM7 net15 B net4 VDD pmos_rvt w=81.0n l=20n nfin=3
MM4 Y D VSS VSS nmos_rvt w=81.0n l=20n nfin=3
MM1 net25 A2 net12 VSS nmos_rvt w=81.0n l=20n nfin=3
MM3 Y B net12 VSS nmos_rvt w=81.0n l=20n nfin=3
MM0 Y A1 net25 VSS nmos_rvt w=81.0n l=20n nfin=3
MM2 net12 C VSS VSS nmos_rvt w=81.0n l=20n nfin=3
.ENDS

.SUBCKT AND2x2_ASAP7_75t_R A B VDD VSS Y
M0 N_M0_d B N_M0_s VSS nmos_rvt L=2e-08 W=8.1e-08 nfin=3
M1 VSS A N_M0_d VSS nmos_rvt L=2e-08 W=8.1e-08 nfin=3
M2 Y N_M0_s VSS VSS nmos_rvt L=2e-08 W=8.1e-08 nfin=3
M3 Y N_M0_s VSS VSS nmos_rvt L=2e-08 W=8.1e-08 nfin=3
M4 N_M0_s B VDD VDD pmos_rvt L=2e-08 W=5.4e-08 nfin=2
M5 VDD A N_M0_s VDD pmos_rvt L=2e-08 W=5.4e-08 nfin=2
M6 Y N_M0_s VDD VDD pmos_rvt L=2e-08 W=8.1e-08 nfin=3
M7 Y N_M0_s VDD VDD pmos_rvt L=2e-08 W=8.1e-08 nfin=3
.ENDS

.SUBCKT AND2x4_ASAP7_75t_R A B VDD VSS Y
M0 VSS A N_M0_s VSS nmos_rvt L=2e-08 W=8.1e-08 nfin=3
M1 N_M0_s B N_M1_s VSS nmos_rvt L=2e-08 W=8.1e-08 nfin=3
M2 N_M2_d B N_M1_s VSS nmos_rvt L=2e-08 W=8.1e-08 nfin=3
M3 VSS A N_M2_d VSS nmos_rvt L=2e-08 W=8.1e-08 nfin=3
M4 Y N_M1_s VSS VSS nmos_rvt L=2e-08 W=8.1e-08 nfin=3
M5 Y N_M1_s VSS VSS nmos_rvt L=2e-08 W=8.1e-08 nfin=3
M6 Y N_M1_s VSS VSS nmos_rvt L=2e-08 W=8.1e-08 nfin=3
M7 Y N_M1_s VSS VSS nmos_rvt L=2e-08 W=8.1e-08 nfin=3
M8 N_M1_s A VDD VDD pmos_rvt L=2e-08 W=5.4e-08 nfin=2
M9 VDD B N_M1_s VDD pmos_rvt L=2e-08 W=5.4e-08 nfin=2
M10 VDD B N_M1_s VDD pmos_rvt L=2e-08 W=5.4e-08 nfin=2
M11 N_M1_s A VDD VDD pmos_rvt L=2e-08 W=5.4e-08 nfin=2
M12 Y N_M1_s VDD VDD pmos_rvt L=2e-08 W=8.1e-08 nfin=3
M13 Y N_M1_s VDD VDD pmos_rvt L=2e-08 W=8.1e-08 nfin=3
M14 Y N_M1_s VDD VDD pmos_rvt L=2e-08 W=8.1e-08 nfin=3
M15 Y N_M1_s VDD VDD pmos_rvt L=2e-08 W=8.1e-08 nfin=3
.ENDS

.SUBCKT AND2x6_ASAP7_75t_R A B VDD VSS Y
MM4 Y net9 VDD VDD pmos_rvt w=486.00n l=20n nfin=18
MM1 net9 B VDD VDD pmos_rvt w=108.00n l=20n nfin=4
MM0 net9 A VDD VDD pmos_rvt w=108.00n l=20n nfin=4
MM5 Y net9 VSS VSS nmos_rvt w=486.00n l=20n nfin=18
MM3 net19 A VSS VSS nmos_rvt w=162.00n l=20n nfin=6
MM2 net9 B net19 VSS nmos_rvt w=162.00n l=20n nfin=6
.ENDS

.SUBCKT AND3x1_ASAP7_75t_R A B C VDD VSS Y
M0 N_M0_d A N_M0_s VSS nmos_rvt L=2e-08 W=8.1e-08 nfin=3
M1 N_M1_d B N_M0_d VSS nmos_rvt L=2e-08 W=8.1e-08 nfin=3
M2 VSS C N_M1_d VSS nmos_rvt L=2e-08 W=8.1e-08 nfin=3
M3 Y N_M0_s VSS VSS nmos_rvt L=2e-08 W=8.1e-08 nfin=3
M4 VDD A N_M0_s VDD pmos_rvt L=2e-08 W=8.1e-08 nfin=3
M5 N_M0_s B VDD VDD pmos_rvt L=2e-08 W=8.1e-08 nfin=3
M6 VDD C N_M0_s VDD pmos_rvt L=2e-08 W=8.1e-08 nfin=3
M7 Y N_M0_s VDD VDD pmos_rvt L=2e-08 W=8.1e-08 nfin=3
.ENDS

.SUBCKT AND3x2_ASAP7_75t_R A B C VDD VSS Y
MM6 Y net61 VDD VDD pmos_rvt w=162.00n l=20n nfin=6
MM5 net61 C VDD VDD pmos_rvt w=81.0n l=20n nfin=3
MM4 net61 B VDD VDD pmos_rvt w=81.0n l=20n nfin=3
MM3 net61 A VDD VDD pmos_rvt w=81.0n l=20n nfin=3
MM7 Y net61 VSS VSS nmos_rvt w=162.00n l=20n nfin=6
MM0 net61 A net72 VSS nmos_rvt w=81.0n l=20n nfin=3
MM1 net72 B net71 VSS nmos_rvt w=81.0n l=20n nfin=3
MM2 net71 C VSS VSS nmos_rvt w=81.0n l=20n nfin=3
.ENDS

.SUBCKT AND3x4_ASAP7_75t_R A B C VDD VSS Y
MM6 Y net83 VDD VDD pmos_rvt w=324.00n l=20n nfin=12
MM5 net83 C VDD VDD pmos_rvt w=81.0n l=20n nfin=3
MM4 net83 B VDD VDD pmos_rvt w=81.0n l=20n nfin=3
MM3 net83 A VDD VDD pmos_rvt w=81.0n l=20n nfin=3
MM7 Y net83 VSS VSS nmos_rvt w=324.00n l=20n nfin=12
MM0 net83 A net89 VSS nmos_rvt w=162.00n l=20n nfin=6
MM1 net89 B net90 VSS nmos_rvt w=162.00n l=20n nfin=6
MM2 net90 C VSS VSS nmos_rvt w=162.00n l=20n nfin=6
.ENDS

.SUBCKT AND4x1_ASAP7_75t_R A B C D VDD VSS Y
M0 N_M0_d A N_M0_s VSS nmos_rvt L=2e-08 W=8.1e-08 nfin=3
M1 N_M1_d B N_M0_d VSS nmos_rvt L=2e-08 W=8.1e-08 nfin=3
M2 N_M2_d C N_M1_d VSS nmos_rvt L=2e-08 W=8.1e-08 nfin=3
M3 VSS D N_M2_d VSS nmos_rvt L=2e-08 W=8.1e-08 nfin=3
M4 Y N_M0_s VSS VSS nmos_rvt L=2e-08 W=8.1e-08 nfin=3
M5 N_M0_s A VDD VDD pmos_rvt L=2e-08 W=8.1e-08 nfin=3
M6 VDD B N_M0_s VDD pmos_rvt L=2e-08 W=8.1e-08 nfin=3
M7 N_M0_s C VDD VDD pmos_rvt L=2e-08 W=8.1e-08 nfin=3
M8 VDD D N_M0_s VDD pmos_rvt L=2e-08 W=8.1e-08 nfin=3
M9 Y N_M0_s VDD VDD pmos_rvt L=2e-08 W=8.1e-08 nfin=3
.ENDS

.SUBCKT AND4x2_ASAP7_75t_R A B C D VDD VSS Y
MM5 net33 A VDD VDD pmos_rvt w=81.0n l=20n nfin=3
MM4 net33 B VDD VDD pmos_rvt w=81.0n l=20n nfin=3
MM3 net33 C VDD VDD pmos_rvt w=81.0n l=20n nfin=3
MM2 net33 D VDD VDD pmos_rvt w=81.0n l=20n nfin=3
MM1 Y net33 VDD VDD pmos_rvt w=162.00n l=20n nfin=6
MM9 net15 D VSS VSS nmos_rvt w=81.0n l=20n nfin=3
MM8 net16 C net15 VSS nmos_rvt w=81.0n l=20n nfin=3
MM7 net17 B net16 VSS nmos_rvt w=81.0n l=20n nfin=3
MM6 net33 A net17 VSS nmos_rvt w=81.0n l=20n nfin=3
MM0 Y net33 VSS VSS nmos_rvt w=162.00n l=20n nfin=6
.ENDS

.SUBCKT AND5x1_ASAP7_75t_R A B C D E VDD VSS Y
M0 N_M0_d A N_M0_s VSS nmos_rvt L=2e-08 W=8.1e-08 nfin=3
M1 N_M1_d B N_M0_d VSS nmos_rvt L=2e-08 W=8.1e-08 nfin=3
M2 N_M2_d C N_M1_d VSS nmos_rvt L=2e-08 W=8.1e-08 nfin=3
M3 N_M3_d D N_M2_d VSS nmos_rvt L=2e-08 W=8.1e-08 nfin=3
M4 VSS E N_M3_d VSS nmos_rvt L=2e-08 W=8.1e-08 nfin=3
M5 Y N_M0_s VSS VSS nmos_rvt L=2e-08 W=8.1e-08 nfin=3
M6 VDD A N_M0_s VDD pmos_rvt L=2e-08 W=5.4e-08 nfin=2
M7 N_M0_s B VDD VDD pmos_rvt L=2e-08 W=5.4e-08 nfin=2
M8 VDD C N_M0_s VDD pmos_rvt L=2e-08 W=5.4e-08 nfin=2
M9 N_M0_s D VDD VDD pmos_rvt L=2e-08 W=5.4e-08 nfin=2
M10 VDD E N_M0_s VDD pmos_rvt L=2e-08 W=5.4e-08 nfin=2
M11 Y N_M0_s VDD VDD pmos_rvt L=2e-08 W=8.1e-08 nfin=3
.ENDS

.SUBCKT AND5x2_ASAP7_75t_R A B C D E VDD VSS Y
MM1 Y net14 VDD VDD pmos_rvt w=162.00n l=20n nfin=6
MM9 net14 E VDD VDD pmos_rvt w=81.0n l=20n nfin=3
MM7 net14 B VDD VDD pmos_rvt w=81.0n l=20n nfin=3
MM2 net14 D VDD VDD pmos_rvt w=81.0n l=20n nfin=3
MM8 net14 C VDD VDD pmos_rvt w=81.0n l=20n nfin=3
MM10 net14 A VDD VDD pmos_rvt w=81.0n l=20n nfin=3
MM11 Y net14 VSS VSS nmos_rvt w=162.00n l=20n nfin=6
MM6 net33 E VSS VSS nmos_rvt w=162.00n l=20n nfin=6
MM5 net34 D net33 VSS nmos_rvt w=162.00n l=20n nfin=6
MM4 net32 B net35 VSS nmos_rvt w=162.00n l=20n nfin=6
MM0 net14 A net32 VSS nmos_rvt w=162.00n l=20n nfin=6
MM3 net35 C net34 VSS nmos_rvt w=162.00n l=20n nfin=6
.ENDS

.SUBCKT AO211x2_ASAP7_75t_R A1 A2 B C VDD VSS Y
MM8 Y net014 VSS VSS nmos_rvt w=162.00n l=20n nfin=6
MM4 net014 C VSS VSS nmos_rvt w=54.0n l=20n nfin=2
MM3 net014 B VSS VSS nmos_rvt w=54.0n l=20n nfin=2
MM2 net23 A2 VSS VSS nmos_rvt w=81.0n l=20n nfin=3
MM24 net014 A1 net23 VSS nmos_rvt w=81.0n l=20n nfin=3
MM7 Y net014 VDD VDD pmos_rvt w=162.00n l=20n nfin=6
MM6 net014 C net22 VDD pmos_rvt w=162.00n l=20n nfin=6
MM5 net22 B net20 VDD pmos_rvt w=162.00n l=20n nfin=6
MM1 net20 A2 VDD VDD pmos_rvt w=162.00n l=20n nfin=6
MM25 net20 A1 VDD VDD pmos_rvt w=162.00n l=20n nfin=6
.ENDS

.SUBCKT AO21x1_ASAP7_75t_R A1 A2 B VDD VSS Y
M0 noxref_9 A1 VSS VSS nmos_rvt L=2e-08 W=8.1e-08 nfin=3
M1 N_M1_d A2 noxref_9 VSS nmos_rvt L=2e-08 W=8.1e-08 nfin=3
M2 VSS B N_M1_d VSS nmos_rvt L=2e-08 W=8.1e-08 nfin=3
M3 Y N_M1_d VSS VSS nmos_rvt L=2e-08 W=8.1e-08 nfin=3
M4 N_M1_d A1 noxref_7 VDD pmos_rvt L=2e-08 W=8.1e-08 nfin=3
M5 noxref_7 A2 N_M1_d VDD pmos_rvt L=2e-08 W=8.1e-08 nfin=3
M6 VDD B noxref_7 VDD pmos_rvt L=2e-08 W=8.1e-08 nfin=3
M7 Y N_M1_d VDD VDD pmos_rvt L=2e-08 W=8.1e-08 nfin=3
.ENDS

.SUBCKT AO21x2_ASAP7_75t_R A1 A2 B VDD VSS Y
MM7 Y net16 VSS VSS nmos_rvt w=162.00n l=20n nfin=6
MM4 net16 B VSS VSS nmos_rvt w=81.0n l=20n nfin=3
MM3 net16 A1 net29 VSS nmos_rvt w=81.0n l=20n nfin=3
MM2 net29 A2 VSS VSS nmos_rvt w=81.0n l=20n nfin=3
MM8 Y net16 VDD VDD pmos_rvt w=162.00n l=20n nfin=6
MM5 net18 A2 net16 VDD pmos_rvt w=81.0n l=20n nfin=3
MM0 VDD B net18 VDD pmos_rvt w=81.0n l=20n nfin=3
MM1 net18 A1 net16 VDD pmos_rvt w=81.0n l=20n nfin=3
.ENDS

.SUBCKT AO221x1_ASAP7_75t_R A1 A2 B1 B2 C VDD VSS Y
M0 noxref_12 B1 N_M0_s VSS nmos_rvt L=2e-08 W=5.4e-08 nfin=2
M1 VSS B2 noxref_12 VSS nmos_rvt L=2e-08 W=5.4e-08 nfin=2
M2 N_M0_s C VSS VSS nmos_rvt L=2e-08 W=5.4e-08 nfin=2
M3 noxref_13 A1 N_M0_s VSS nmos_rvt L=2e-08 W=5.4e-08 nfin=2
M4 VSS A2 noxref_13 VSS nmos_rvt L=2e-08 W=5.4e-08 nfin=2
M5 Y N_M0_s VSS VSS nmos_rvt L=2e-08 W=8.1e-08 nfin=3
M6 N_M0_s B1 noxref_9 VDD pmos_rvt L=2e-08 W=8.1e-08 nfin=3
M7 noxref_9 B2 N_M0_s VDD pmos_rvt L=2e-08 W=8.1e-08 nfin=3
M8 noxref_10 C noxref_9 VDD pmos_rvt L=2e-08 W=8.1e-08 nfin=3
M9 VDD A1 noxref_10 VDD pmos_rvt L=2e-08 W=8.1e-08 nfin=3
M10 noxref_10 A2 VDD VDD pmos_rvt L=2e-08 W=8.1e-08 nfin=3
M11 Y N_M0_s VDD VDD pmos_rvt L=2e-08 W=8.1e-08 nfin=3
.ENDS

.SUBCKT AO221x2_ASAP7_75t_R A1 A2 B1 B2 C VDD VSS Y
M0 noxref_12 B1 N_M0_s VSS nmos_rvt L=2e-08 W=5.4e-08 nfin=2
M1 VSS B2 noxref_12 VSS nmos_rvt L=2e-08 W=5.4e-08 nfin=2
M2 N_M0_s C VSS VSS nmos_rvt L=2e-08 W=5.4e-08 nfin=2
M3 noxref_13 A1 N_M0_s VSS nmos_rvt L=2e-08 W=5.4e-08 nfin=2
M4 VSS A2 noxref_13 VSS nmos_rvt L=2e-08 W=5.4e-08 nfin=2
M5 Y N_M0_s VSS VSS nmos_rvt L=2e-08 W=8.1e-08 nfin=3
M6 Y N_M0_s VSS VSS nmos_rvt L=2e-08 W=8.1e-08 nfin=3
M7 N_M0_s B1 noxref_9 VDD pmos_rvt L=2e-08 W=8.1e-08 nfin=3
M8 noxref_9 B2 N_M0_s VDD pmos_rvt L=2e-08 W=8.1e-08 nfin=3
M9 noxref_10 C noxref_9 VDD pmos_rvt L=2e-08 W=8.1e-08 nfin=3
M10 VDD A1 noxref_10 VDD pmos_rvt L=2e-08 W=8.1e-08 nfin=3
M11 noxref_10 A2 VDD VDD pmos_rvt L=2e-08 W=8.1e-08 nfin=3
M12 Y N_M0_s VDD VDD pmos_rvt L=2e-08 W=8.1e-08 nfin=3
M13 Y N_M0_s VDD VDD pmos_rvt L=2e-08 W=8.1e-08 nfin=3
.ENDS

.SUBCKT AO222x2_ASAP7_75t_R A1 A2 B1 B2 C1 C2 VDD VSS Y
MM8 Y net23 VDD VDD pmos_rvt w=162.00n l=20n nfin=6
MM5 net23 C2 net17 VDD pmos_rvt w=81.0n l=20n nfin=3
MM4 net17 B2 net18 VDD pmos_rvt w=81.0n l=20n nfin=3
MM3 net18 A2 VDD VDD pmos_rvt w=81.0n l=20n nfin=3
MM2 net23 C1 net17 VDD pmos_rvt w=81.0n l=20n nfin=3
MM1 net17 B1 net18 VDD pmos_rvt w=81.0n l=20n nfin=3
MM0 net18 A1 VDD VDD pmos_rvt w=81.0n l=20n nfin=3
MM14 net37 B2 VSS VSS nmos_rvt w=81.0n l=20n nfin=3
MM13 net23 B1 net37 VSS nmos_rvt w=81.0n l=20n nfin=3
MM11 net36 C2 VSS VSS nmos_rvt w=81.0n l=20n nfin=3
MM10 net23 C1 net36 VSS nmos_rvt w=81.0n l=20n nfin=3
MM9 Y net23 VSS VSS nmos_rvt w=162.00n l=20n nfin=6
MM7 net38 A2 VSS VSS nmos_rvt w=81.0n l=20n nfin=3
MM6 net23 A1 net38 VSS nmos_rvt w=81.0n l=20n nfin=3
.ENDS

.SUBCKT AO22x1_ASAP7_75t_R A1 A2 B1 B2 VDD VSS Y
M0 noxref_10 A1 VSS VSS nmos_rvt L=2e-08 W=5.4e-08 nfin=2
M1 N_M1_d A2 noxref_10 VSS nmos_rvt L=2e-08 W=5.4e-08 nfin=2
M2 noxref_11 B2 N_M1_d VSS nmos_rvt L=2e-08 W=5.4e-08 nfin=2
M3 VSS B1 noxref_11 VSS nmos_rvt L=2e-08 W=5.4e-08 nfin=2
M4 Y N_M1_d VSS VSS nmos_rvt L=2e-08 W=8.1e-08 nfin=3
M5 VDD A1 noxref_8 VDD pmos_rvt L=2e-08 W=5.4e-08 nfin=2
M6 noxref_8 A2 VDD VDD pmos_rvt L=2e-08 W=5.4e-08 nfin=2
M7 N_M1_d B2 noxref_8 VDD pmos_rvt L=2e-08 W=5.4e-08 nfin=2
M8 noxref_8 B1 N_M1_d VDD pmos_rvt L=2e-08 W=5.4e-08 nfin=2
M9 Y N_M1_d VDD VDD pmos_rvt L=2e-08 W=8.1e-08 nfin=3
.ENDS

.SUBCKT AO22x2_ASAP7_75t_R A1 A2 B1 B2 VDD VSS Y
MM5 net18 B2 net13 VDD pmos_rvt w=81.0n l=20n nfin=3
MM4 net18 B1 net13 VDD pmos_rvt w=81.0n l=20n nfin=3
MM3 net13 A2 VDD VDD pmos_rvt w=81.0n l=20n nfin=3
MM1 Y net18 VDD VDD pmos_rvt w=162.00n l=20n nfin=6
MM2 net13 A1 VDD VDD pmos_rvt w=81.0n l=20n nfin=3
MM9 net29 B1 VSS VSS nmos_rvt w=81.0n l=20n nfin=3
MM8 net30 A1 VSS VSS nmos_rvt w=81.0n l=20n nfin=3
MM7 net18 B2 net29 VSS nmos_rvt w=81.0n l=20n nfin=3
MM6 net18 A2 net30 VSS nmos_rvt w=81.0n l=20n nfin=3
MM0 Y net18 VSS VSS nmos_rvt w=162.00n l=20n nfin=6
.ENDS

.SUBCKT AO31x2_ASAP7_75t_R A1 A2 A3 B VDD VSS Y
MM0 Y net18 VSS VSS nmos_rvt w=162.00n l=20n nfin=6
MM5 net18 B VSS VSS nmos_rvt w=54.0n l=20n nfin=2
MM4 net29 A3 VSS VSS nmos_rvt w=162.00n l=20n nfin=6
MM2 net18 A1 net30 VSS nmos_rvt w=162.00n l=20n nfin=6
MM3 net30 A2 net29 VSS nmos_rvt w=162.00n l=20n nfin=6
MM1 Y net18 VDD VDD pmos_rvt w=162.00n l=20n nfin=6
MM9 net18 B net23 VDD pmos_rvt w=162.00n l=20n nfin=6
MM10 net23 A3 VDD VDD pmos_rvt w=162.00n l=20n nfin=6
MM7 net23 A2 VDD VDD pmos_rvt w=162.00n l=20n nfin=6
MM6 net23 A1 VDD VDD pmos_rvt w=162.00n l=20n nfin=6
.ENDS

.SUBCKT AO322x2_ASAP7_75t_R A1 A2 A3 B1 B2 C1 C2 VDD VSS Y
MM16 Y net25 VSS VSS nmos_rvt w=162.00n l=20n nfin=6
MM6 net50 C2 VSS VSS nmos_rvt w=54.0n l=20n nfin=2
MM5 net25 C1 net50 VSS nmos_rvt w=54.0n l=20n nfin=2
MM4 net51 B2 VSS VSS nmos_rvt w=54.0n l=20n nfin=2
MM3 net25 B1 net51 VSS nmos_rvt w=54.0n l=20n nfin=2
MM2 net52 A3 VSS VSS nmos_rvt w=81.0n l=20n nfin=3
MM1 net49 A2 net52 VSS nmos_rvt w=81.0n l=20n nfin=3
MM0 net25 A1 net49 VSS nmos_rvt w=81.0n l=20n nfin=3
MM17 Y net25 VDD VDD pmos_rvt w=162.00n l=20n nfin=6
MM13 net27 A3 VDD VDD pmos_rvt w=81.0n l=20n nfin=3
MM12 net25 C2 net53 VDD pmos_rvt w=81.0n l=20n nfin=3
MM11 net53 B2 net27 VDD pmos_rvt w=81.0n l=20n nfin=3
MM10 net27 A2 VDD VDD pmos_rvt w=81.0n l=20n nfin=3
MM9 net25 C1 net53 VDD pmos_rvt w=81.0n l=20n nfin=3
MM8 net53 B1 net27 VDD pmos_rvt w=81.0n l=20n nfin=3
MM7 net27 A1 VDD VDD pmos_rvt w=81.0n l=20n nfin=3
.ENDS

.SUBCKT AO32x1_ASAP7_75t_R A1 A2 A3 B1 B2 VDD VSS Y
M0 VSS N_M0_g Y VSS nmos_rvt L=2e-08 W=8.1e-08 nfin=3
M1 noxref_11 A3 VSS VSS nmos_rvt L=2e-08 W=8.1e-08 nfin=3
M2 noxref_12 A2 noxref_11 VSS nmos_rvt L=2e-08 W=8.1e-08 nfin=3
M3 N_M0_g A1 noxref_12 VSS nmos_rvt L=2e-08 W=8.1e-08 nfin=3
M4 noxref_13 B1 N_M0_g VSS nmos_rvt L=2e-08 W=5.4e-08 nfin=2
M5 VSS B2 noxref_13 VSS nmos_rvt L=2e-08 W=5.4e-08 nfin=2
M6 VDD N_M0_g Y VDD pmos_rvt L=2e-08 W=8.1e-08 nfin=3
M7 noxref_10 A3 VDD VDD pmos_rvt L=2e-08 W=5.4e-08 nfin=2
M8 VDD A2 noxref_10 VDD pmos_rvt L=2e-08 W=5.4e-08 nfin=2
M9 noxref_10 A1 VDD VDD pmos_rvt L=2e-08 W=5.4e-08 nfin=2
M10 N_M0_g B1 noxref_10 VDD pmos_rvt L=2e-08 W=5.4e-08 nfin=2
M11 noxref_10 B2 N_M0_g VDD pmos_rvt L=2e-08 W=5.4e-08 nfin=2
.ENDS

.SUBCKT AO32x2_ASAP7_75t_R A1 A2 A3 B1 B2 VDD VSS Y
MM21 Y net08 VSS VSS nmos_rvt w=162.00n l=20n nfin=6
MM0 net08 A1 net24 VSS nmos_rvt w=81.0n l=20n nfin=3
MM2 net24 A2 net25 VSS nmos_rvt w=81.0n l=20n nfin=3
MM3 net25 A3 VSS VSS nmos_rvt w=81.0n l=20n nfin=3
MM18 net26 B2 VSS VSS nmos_rvt w=54.0n l=20n nfin=2
MM13 net08 B1 net26 VSS nmos_rvt w=54.0n l=20n nfin=2
MM20 Y net08 VDD VDD pmos_rvt w=162.00n l=20n nfin=6
MM1 net10 A2 VDD VDD pmos_rvt w=54.0n l=20n nfin=2
MM4 net10 A3 VDD VDD pmos_rvt w=54.0n l=20n nfin=2
MM5 net10 A1 VDD VDD pmos_rvt w=54.0n l=20n nfin=2
MM15 net08 B2 net10 VDD pmos_rvt w=54.0n l=20n nfin=2
MM14 net08 B1 net10 VDD pmos_rvt w=54.0n l=20n nfin=2
.ENDS

.SUBCKT AO331x1_ASAP7_75t_R A1 A2 A3 B1 B2 B3 C VDD VSS Y
MM0 Y yb VDD VDD pmos_rvt w=81.0n l=20n nfin=3
MM23 net24 B3 net034 VDD pmos_rvt w=81.0n l=20n nfin=3
MM26 net034 A3 VDD VDD pmos_rvt w=81.0n l=20n nfin=3
MM21 net24 B2 net034 VDD pmos_rvt w=81.0n l=20n nfin=3
MM25 net034 A2 VDD VDD pmos_rvt w=81.0n l=20n nfin=3
MM27 yb C net24 VDD pmos_rvt w=81.0n l=20n nfin=3
MM20 net24 B1 net034 VDD pmos_rvt w=81.0n l=20n nfin=3
MM24 net034 A1 VDD VDD pmos_rvt w=81.0n l=20n nfin=3
MM1 Y yb VSS VSS nmos_rvt w=81.0n l=20n nfin=3
MM22 yb C VSS VSS nmos_rvt w=81.0n l=20n nfin=3
MM19 net31 B3 VSS VSS nmos_rvt w=81.0n l=20n nfin=3
MM18 net32 B2 net31 VSS nmos_rvt w=81.0n l=20n nfin=3
MM17 yb B1 net32 VSS nmos_rvt w=81.0n l=20n nfin=3
MM16 n2 A3 VSS VSS nmos_rvt w=81.0n l=20n nfin=3
MM15 n1 A2 n2 VSS nmos_rvt w=81.0n l=20n nfin=3
MM14 yb A1 n1 VSS nmos_rvt w=81.0n l=20n nfin=3
.ENDS

.SUBCKT AO331x2_ASAP7_75t_R A1 A2 A3 B1 B2 B3 C VDD VSS Y
MM0 Y yb VDD VDD pmos_rvt w=162.00n l=20n nfin=6
MM23 net24 B3 net034 VDD pmos_rvt w=81.0n l=20n nfin=3
MM26 net034 A3 VDD VDD pmos_rvt w=81.0n l=20n nfin=3
MM21 net24 B2 net034 VDD pmos_rvt w=81.0n l=20n nfin=3
MM25 net034 A2 VDD VDD pmos_rvt w=81.0n l=20n nfin=3
MM27 yb C net24 VDD pmos_rvt w=81.0n l=20n nfin=3
MM20 net24 B1 net034 VDD pmos_rvt w=81.0n l=20n nfin=3
MM24 net034 A1 VDD VDD pmos_rvt w=81.0n l=20n nfin=3
MM1 Y yb VSS VSS nmos_rvt w=162.00n l=20n nfin=6
MM22 yb C VSS VSS nmos_rvt w=81.0n l=20n nfin=3
MM19 net31 B3 VSS VSS nmos_rvt w=81.0n l=20n nfin=3
MM18 net32 B2 net31 VSS nmos_rvt w=81.0n l=20n nfin=3
MM17 yb B1 net32 VSS nmos_rvt w=81.0n l=20n nfin=3
MM16 n2 A3 VSS VSS nmos_rvt w=81.0n l=20n nfin=3
MM15 n1 A2 n2 VSS nmos_rvt w=81.0n l=20n nfin=3
MM14 yb A1 n1 VSS nmos_rvt w=81.0n l=20n nfin=3
.ENDS

.SUBCKT AO332x1_ASAP7_75t_R A1 A2 A3 B1 B2 B3 C1 C2 VDD VSS Y
MM17 net018 C1 net061 VSS nmos_rvt w=81.0n l=20n nfin=3
MM16 net061 C2 VSS VSS nmos_rvt w=81.0n l=20n nfin=3
MM13 Y net018 VSS VSS nmos_rvt w=81.0n l=20n nfin=3
MM12 net018 B1 net063 VSS nmos_rvt w=81.0n l=20n nfin=3
MM11 net063 B2 net064 VSS nmos_rvt w=81.0n l=20n nfin=3
MM10 net064 B3 VSS VSS nmos_rvt w=81.0n l=20n nfin=3
MM3 net25 A3 VSS VSS nmos_rvt w=81.0n l=20n nfin=3
MM14 net018 A1 net26 VSS nmos_rvt w=81.0n l=20n nfin=3
MM2 net26 A2 net25 VSS nmos_rvt w=81.0n l=20n nfin=3
MM15 Y net018 VDD VDD pmos_rvt w=81.0n l=20n nfin=3
MM9 net031 A1 VDD VDD pmos_rvt w=81.0n l=20n nfin=3
MM8 net031 A2 VDD VDD pmos_rvt w=81.0n l=20n nfin=3
MM7 net031 A3 VDD VDD pmos_rvt w=81.0n l=20n nfin=3
MM6 net030 B1 net031 VDD pmos_rvt w=81.0n l=20n nfin=3
MM1 net018 C1 net030 VDD pmos_rvt w=81.0n l=20n nfin=3
MM5 net030 B2 net031 VDD pmos_rvt w=81.0n l=20n nfin=3
MM4 net030 B3 net031 VDD pmos_rvt w=81.0n l=20n nfin=3
MM0 net018 C2 net030 VDD pmos_rvt w=81.0n l=20n nfin=3
.ENDS

.SUBCKT AO332x2_ASAP7_75t_R A1 A2 A3 B1 B2 B3 C1 C2 VDD VSS Y
MM17 net018 C1 net061 VSS nmos_rvt w=81.0n l=20n nfin=3
MM16 net061 C2 VSS VSS nmos_rvt w=81.0n l=20n nfin=3
MM13 Y net018 VSS VSS nmos_rvt w=162.00n l=20n nfin=6
MM12 net018 B1 net063 VSS nmos_rvt w=81.0n l=20n nfin=3
MM11 net063 B2 net064 VSS nmos_rvt w=81.0n l=20n nfin=3
MM10 net064 B3 VSS VSS nmos_rvt w=81.0n l=20n nfin=3
MM3 net25 A3 VSS VSS nmos_rvt w=81.0n l=20n nfin=3
MM14 net018 A1 net26 VSS nmos_rvt w=81.0n l=20n nfin=3
MM2 net26 A2 net25 VSS nmos_rvt w=81.0n l=20n nfin=3
MM15 Y net018 VDD VDD pmos_rvt w=162.00n l=20n nfin=6
MM9 net031 A1 VDD VDD pmos_rvt w=81.0n l=20n nfin=3
MM8 net031 A2 VDD VDD pmos_rvt w=81.0n l=20n nfin=3
MM7 net031 A3 VDD VDD pmos_rvt w=81.0n l=20n nfin=3
MM6 net030 B1 net031 VDD pmos_rvt w=81.0n l=20n nfin=3
MM1 net018 C1 net030 VDD pmos_rvt w=81.0n l=20n nfin=3
MM5 net030 B2 net031 VDD pmos_rvt w=81.0n l=20n nfin=3
MM4 net030 B3 net031 VDD pmos_rvt w=81.0n l=20n nfin=3
MM0 net018 C2 net030 VDD pmos_rvt w=81.0n l=20n nfin=3
.ENDS

.SUBCKT AO333x1_ASAP7_75t_R A1 A2 A3 B1 B2 B3 C1 C2 C3 VDD VSS Y
MM3 Y net40 VSS VSS nmos_rvt w=81.0n l=20n nfin=3
MM0 net40 C1 net55 VSS nmos_rvt w=81.0n l=20n nfin=3
MM1 net55 C2 net54 VSS nmos_rvt w=81.0n l=20n nfin=3
MM2 net54 C3 VSS VSS nmos_rvt w=81.0n l=20n nfin=3
MM19 net58 A3 VSS VSS nmos_rvt w=81.0n l=20n nfin=3
MM18 net59 A2 net58 VSS nmos_rvt w=81.0n l=20n nfin=3
MM14 net40 A1 net59 VSS nmos_rvt w=81.0n l=20n nfin=3
MM10 net40 B3 net56 VSS nmos_rvt w=81.0n l=20n nfin=3
MM9 net56 B2 net57 VSS nmos_rvt w=81.0n l=20n nfin=3
MM8 net57 B1 VSS VSS nmos_rvt w=81.0n l=20n nfin=3
MM7 net40 C1 net22 VDD pmos_rvt w=81.0n l=20n nfin=3
MM6 net40 C2 net22 VDD pmos_rvt w=81.0n l=20n nfin=3
MM5 net40 C3 net22 VDD pmos_rvt w=81.0n l=20n nfin=3
MM4 Y net40 VDD VDD pmos_rvt w=81.0n l=20n nfin=3
MM17 net24 A3 VDD VDD pmos_rvt w=81.0n l=20n nfin=3
MM16 net24 A2 VDD VDD pmos_rvt w=81.0n l=20n nfin=3
MM15 net24 A1 VDD VDD pmos_rvt w=81.0n l=20n nfin=3
MM13 net22 B3 net24 VDD pmos_rvt w=81.0n l=20n nfin=3
MM12 net22 B2 net24 VDD pmos_rvt w=81.0n l=20n nfin=3
MM11 net22 B1 net24 VDD pmos_rvt w=81.0n l=20n nfin=3
.ENDS

.SUBCKT AO333x2_ASAP7_75t_R A1 A2 A3 B1 B2 B3 C1 C2 C3 VDD VSS Y
MM3 Y net40 VSS VSS nmos_rvt w=162.00n l=20n nfin=6
MM0 net40 C1 net55 VSS nmos_rvt w=81.0n l=20n nfin=3
MM1 net55 C2 net54 VSS nmos_rvt w=81.0n l=20n nfin=3
MM2 net54 C3 VSS VSS nmos_rvt w=81.0n l=20n nfin=3
MM19 net58 A3 VSS VSS nmos_rvt w=81.0n l=20n nfin=3
MM18 net59 A2 net58 VSS nmos_rvt w=81.0n l=20n nfin=3
MM14 net40 A1 net59 VSS nmos_rvt w=81.0n l=20n nfin=3
MM10 net40 B3 net56 VSS nmos_rvt w=81.0n l=20n nfin=3
MM9 net56 B2 net57 VSS nmos_rvt w=81.0n l=20n nfin=3
MM8 net57 B1 VSS VSS nmos_rvt w=81.0n l=20n nfin=3
MM7 net40 C1 net22 VDD pmos_rvt w=81.0n l=20n nfin=3
MM6 net40 C2 net22 VDD pmos_rvt w=81.0n l=20n nfin=3
MM5 net40 C3 net22 VDD pmos_rvt w=81.0n l=20n nfin=3
MM4 Y net40 VDD VDD pmos_rvt w=162.00n l=20n nfin=6
MM17 net24 A3 VDD VDD pmos_rvt w=81.0n l=20n nfin=3
MM16 net24 A2 VDD VDD pmos_rvt w=81.0n l=20n nfin=3
MM15 net24 A1 VDD VDD pmos_rvt w=81.0n l=20n nfin=3
MM13 net22 B3 net24 VDD pmos_rvt w=81.0n l=20n nfin=3
MM12 net22 B2 net24 VDD pmos_rvt w=81.0n l=20n nfin=3
MM11 net22 B1 net24 VDD pmos_rvt w=81.0n l=20n nfin=3
.ENDS

.SUBCKT AO33x2_ASAP7_75t_R A1 A2 A3 B1 B2 B3 VDD VSS Y
MM25 Y net020 VDD VDD pmos_rvt w=162.00n l=20n nfin=6
MM6 net020 B3 net15 VDD pmos_rvt w=54.0n l=20n nfin=2
MM5 net15 A3 VDD VDD pmos_rvt w=54.0n l=20n nfin=2
MM4 net15 A2 VDD VDD pmos_rvt w=54.0n l=20n nfin=2
MM3 net020 B2 net15 VDD pmos_rvt w=54.0n l=20n nfin=2
MM2 net020 B1 net15 VDD pmos_rvt w=54.0n l=20n nfin=2
MM21 net15 A1 VDD VDD pmos_rvt w=54.0n l=20n nfin=2
MM24 Y net020 VSS VSS nmos_rvt w=162.00n l=20n nfin=6
MM10 net020 B1 net39 VSS nmos_rvt w=81.0n l=20n nfin=3
MM9 net022 B3 VSS VSS nmos_rvt w=81.0n l=20n nfin=3
MM8 net39 B2 net022 VSS nmos_rvt w=81.0n l=20n nfin=3
MM7 net020 A1 net40 VSS nmos_rvt w=81.0n l=20n nfin=3
MM1 net024 A3 VSS VSS nmos_rvt w=81.0n l=20n nfin=3
MM0 net40 A2 net024 VSS nmos_rvt w=81.0n l=20n nfin=3
.ENDS

.SUBCKT AOI211x1_ASAP7_75t_R A1 A2 B C VDD VSS Y
MM20 Y C VSS VSS nmos_rvt w=81.0n l=20n nfin=3
MM3 Y B VSS VSS nmos_rvt w=81.0n l=20n nfin=3
MM4 Y A2 net32 VSS nmos_rvt w=81.0n l=20n nfin=3
MM5 net32 A1 VSS VSS nmos_rvt w=81.0n l=20n nfin=3
MM21 net17 A2 VDD VDD pmos_rvt w=162.00n l=20n nfin=6
MM0 net17 A1 VDD VDD pmos_rvt w=162.00n l=20n nfin=6
MM6 net34 B net17 VDD pmos_rvt w=162.00n l=20n nfin=6
MM7 Y C net34 VDD pmos_rvt w=162.00n l=20n nfin=6
.ENDS

.SUBCKT AOI211xp5_ASAP7_75t_R A1 A2 B C VDD VSS Y
MM20 Y C VSS VSS nmos_rvt w=54.0n l=20n nfin=2
MM3 Y B VSS VSS nmos_rvt w=54.0n l=20n nfin=2
MM4 Y A2 net32 VSS nmos_rvt w=54.0n l=20n nfin=2
MM5 net32 A1 VSS VSS nmos_rvt w=54.0n l=20n nfin=2
MM21 net17 A2 VDD VDD pmos_rvt w=81.0n l=20n nfin=3
MM0 net17 A1 VDD VDD pmos_rvt w=81.0n l=20n nfin=3
MM6 net34 B net17 VDD pmos_rvt w=81.0n l=20n nfin=3
MM7 Y C net34 VDD pmos_rvt w=81.0n l=20n nfin=3
.ENDS

.SUBCKT AOI21x1_ASAP7_75t_R A1 A2 B VDD VSS Y
M0 Y B VSS VSS nmos_rvt L=2e-08 W=5.4e-08 nfin=2
M1 Y A1 noxref_8 VSS nmos_rvt L=2e-08 W=8.1e-08 nfin=3
M2 noxref_8 A2 VSS VSS nmos_rvt L=2e-08 W=8.1e-08 nfin=3
M3 noxref_9 A2 VSS VSS nmos_rvt L=2e-08 W=8.1e-08 nfin=3
M4 Y A1 noxref_9 VSS nmos_rvt L=2e-08 W=8.1e-08 nfin=3
M5 Y B VSS VSS nmos_rvt L=2e-08 W=5.4e-08 nfin=2
M6 noxref_6 B Y VDD pmos_rvt L=2e-08 W=8.1e-08 nfin=3
M7 VDD A1 noxref_6 VDD pmos_rvt L=2e-08 W=8.1e-08 nfin=3
M8 noxref_6 A2 VDD VDD pmos_rvt L=2e-08 W=8.1e-08 nfin=3
M9 noxref_6 A2 VDD VDD pmos_rvt L=2e-08 W=8.1e-08 nfin=3
M10 VDD A1 noxref_6 VDD pmos_rvt L=2e-08 W=8.1e-08 nfin=3
M11 noxref_6 B Y VDD pmos_rvt L=2e-08 W=8.1e-08 nfin=3
.ENDS

.SUBCKT AOI21xp33_ASAP7_75t_R A1 A2 B VDD VSS Y
MM4 Y B VSS VSS nmos_rvt w=54.0n l=20n nfin=2
MM3 Y A1 net29 VSS nmos_rvt w=54.0n l=20n nfin=2
MM2 net29 A2 VSS VSS nmos_rvt w=54.0n l=20n nfin=2
MM5 net18 A2 VDD VDD pmos_rvt w=54.0n l=20n nfin=2
MM0 Y B net18 VDD pmos_rvt w=54.0n l=20n nfin=2
MM1 net18 A1 VDD VDD pmos_rvt w=54.0n l=20n nfin=2
.ENDS

.SUBCKT AOI21xp5_ASAP7_75t_R A1 A2 B VDD VSS Y
MM4 Y B VSS VSS nmos_rvt w=54.0n l=20n nfin=2
MM3 Y A1 net29 VSS nmos_rvt w=81.0n l=20n nfin=3
MM2 net29 A2 VSS VSS nmos_rvt w=81.0n l=20n nfin=3
MM5 net18 A2 VDD VDD pmos_rvt w=81.0n l=20n nfin=3
MM0 Y B net18 VDD pmos_rvt w=81.0n l=20n nfin=3
MM1 net18 A1 VDD VDD pmos_rvt w=81.0n l=20n nfin=3
.ENDS

.SUBCKT AOI221x1_ASAP7_75t_R A1 A2 B1 B2 C VDD VSS Y
M0 noxref_11 A2 VSS VSS nmos_rvt L=2e-08 W=8.1e-08 nfin=3
M1 Y A1 noxref_11 VSS nmos_rvt L=2e-08 W=8.1e-08 nfin=3
M2 noxref_12 B1 Y VSS nmos_rvt L=2e-08 W=8.1e-08 nfin=3
M3 VSS B2 noxref_12 VSS nmos_rvt L=2e-08 W=8.1e-08 nfin=3
M4 VSS C Y VSS nmos_rvt L=2e-08 W=5.4e-08 nfin=2
M5 VDD A2 noxref_8 VDD pmos_rvt L=2e-08 W=8.1e-08 nfin=3
M6 VDD A2 noxref_8 VDD pmos_rvt L=2e-08 W=8.1e-08 nfin=3
M7 VDD A1 noxref_8 VDD pmos_rvt L=2e-08 W=8.1e-08 nfin=3
M8 VDD A1 noxref_8 VDD pmos_rvt L=2e-08 W=8.1e-08 nfin=3
M9 noxref_9 B1 noxref_8 VDD pmos_rvt L=2e-08 W=8.1e-08 nfin=3
M10 noxref_9 B1 noxref_8 VDD pmos_rvt L=2e-08 W=8.1e-08 nfin=3
M11 noxref_9 B2 noxref_8 VDD pmos_rvt L=2e-08 W=8.1e-08 nfin=3
M12 noxref_9 B2 noxref_8 VDD pmos_rvt L=2e-08 W=8.1e-08 nfin=3
M13 Y C noxref_9 VDD pmos_rvt L=2e-08 W=8.1e-08 nfin=3
M14 Y C noxref_9 VDD pmos_rvt L=2e-08 W=8.1e-08 nfin=3
.ENDS

.SUBCKT AOI221xp5_ASAP7_75t_R A1 A2 B1 B2 C VDD VSS Y
MM28 Y C VSS VSS nmos_rvt w=54.0n l=20n nfin=2
MM27 net23 B2 VSS VSS nmos_rvt w=54.0n l=20n nfin=2
MM26 Y B1 net23 VSS nmos_rvt w=54.0n l=20n nfin=2
MM2 Y A1 net24 VSS nmos_rvt w=54.0n l=20n nfin=2
MM0 net24 A2 VSS VSS nmos_rvt w=54.0n l=20n nfin=2
MM1 net012 C net16 VDD pmos_rvt w=81.0n l=20n nfin=3
MM32 net16 B2 Y VDD pmos_rvt w=81.0n l=20n nfin=3
MM31 net012 A2 VDD VDD pmos_rvt w=81.0n l=20n nfin=3
MM30 net16 B1 Y VDD pmos_rvt w=81.0n l=20n nfin=3
MM29 net012 A1 VDD VDD pmos_rvt w=81.0n l=20n nfin=3
.ENDS

.SUBCKT AOI222xp33_ASAP7_75t_R A1 A2 B1 B2 C1 C2 VDD VSS Y
MM6 net50 C2 VSS VSS nmos_rvt w=54.0n l=20n nfin=2
MM5 Y C1 net50 VSS nmos_rvt w=54.0n l=20n nfin=2
MM4 net51 B2 VSS VSS nmos_rvt w=54.0n l=20n nfin=2
MM3 Y B1 net51 VSS nmos_rvt w=54.0n l=20n nfin=2
MM1 net49 A2 VSS VSS nmos_rvt w=54.0n l=20n nfin=2
MM0 Y A1 net49 VSS nmos_rvt w=54.0n l=20n nfin=2
MM12 Y A2 net53 VDD pmos_rvt w=81.0n l=20n nfin=3
MM11 net53 B2 net27 VDD pmos_rvt w=81.0n l=20n nfin=3
MM10 net27 C2 VDD VDD pmos_rvt w=81.0n l=20n nfin=3
MM9 Y A1 net53 VDD pmos_rvt w=81.0n l=20n nfin=3
MM8 net53 B1 net27 VDD pmos_rvt w=81.0n l=20n nfin=3
MM7 net27 C1 VDD VDD pmos_rvt w=81.0n l=20n nfin=3
.ENDS

.SUBCKT AOI22x1_ASAP7_75t_R A1 A2 B1 B2 VDD VSS Y
M0 Y B2 noxref_9 VSS nmos_rvt L=2e-08 W=8.1e-08 nfin=3
M1 noxref_9 B1 VSS VSS nmos_rvt L=2e-08 W=8.1e-08 nfin=3
M2 noxref_10 B1 VSS VSS nmos_rvt L=2e-08 W=8.1e-08 nfin=3
M3 Y B2 noxref_10 VSS nmos_rvt L=2e-08 W=8.1e-08 nfin=3
M4 Y A2 noxref_11 VSS nmos_rvt L=2e-08 W=8.1e-08 nfin=3
M5 noxref_11 A1 VSS VSS nmos_rvt L=2e-08 W=8.1e-08 nfin=3
M6 noxref_12 A1 VSS VSS nmos_rvt L=2e-08 W=8.1e-08 nfin=3
M7 Y A2 noxref_12 VSS nmos_rvt L=2e-08 W=8.1e-08 nfin=3
M8 VDD B2 noxref_7 VDD pmos_rvt L=2e-08 W=8.1e-08 nfin=3
M9 noxref_7 B1 VDD VDD pmos_rvt L=2e-08 W=8.1e-08 nfin=3
M10 noxref_7 B1 VDD VDD pmos_rvt L=2e-08 W=8.1e-08 nfin=3
M11 VDD B2 noxref_7 VDD pmos_rvt L=2e-08 W=8.1e-08 nfin=3
M12 Y A2 noxref_7 VDD pmos_rvt L=2e-08 W=8.1e-08 nfin=3
M13 noxref_7 A1 Y VDD pmos_rvt L=2e-08 W=8.1e-08 nfin=3
M14 noxref_7 A1 Y VDD pmos_rvt L=2e-08 W=8.1e-08 nfin=3
M15 Y A2 noxref_7 VDD pmos_rvt L=2e-08 W=8.1e-08 nfin=3
.ENDS

.SUBCKT AOI22xp33_ASAP7_75t_R A1 A2 B1 B2 VDD VSS Y
MM5 Y B2 net13 VDD pmos_rvt w=54.0n l=20n nfin=2
MM4 Y B1 net13 VDD pmos_rvt w=54.0n l=20n nfin=2
MM3 net13 A2 VDD VDD pmos_rvt w=54.0n l=20n nfin=2
MM2 net13 A1 VDD VDD pmos_rvt w=54.0n l=20n nfin=2
MM9 net29 B1 VSS VSS nmos_rvt w=54.0n l=20n nfin=2
MM8 net30 A1 VSS VSS nmos_rvt w=54.0n l=20n nfin=2
MM7 Y B2 net29 VSS nmos_rvt w=54.0n l=20n nfin=2
MM6 Y A2 net30 VSS nmos_rvt w=54.0n l=20n nfin=2
.ENDS

.SUBCKT AOI22xp5_ASAP7_75t_R A1 A2 B1 B2 VDD VSS Y
MM5 Y B2 net13 VDD pmos_rvt w=81.0n l=20n nfin=3
MM4 Y B1 net13 VDD pmos_rvt w=81.0n l=20n nfin=3
MM3 net13 A2 VDD VDD pmos_rvt w=81.0n l=20n nfin=3
MM2 net13 A1 VDD VDD pmos_rvt w=81.0n l=20n nfin=3
MM9 net29 B1 VSS VSS nmos_rvt w=81.0n l=20n nfin=3
MM8 net30 A1 VSS VSS nmos_rvt w=81.0n l=20n nfin=3
MM7 Y B2 net29 VSS nmos_rvt w=81.0n l=20n nfin=3
MM6 Y A2 net30 VSS nmos_rvt w=81.0n l=20n nfin=3
.ENDS

.SUBCKT AOI311xp33_ASAP7_75t_R A1 A2 A3 B C VDD VSS Y
MM0 Y C VSS VSS nmos_rvt w=54.0n l=20n nfin=2
MM5 Y B VSS VSS nmos_rvt w=54.0n l=20n nfin=2
MM4 net29 A3 VSS VSS nmos_rvt w=81.0n l=20n nfin=3
MM2 Y A1 net30 VSS nmos_rvt w=81.0n l=20n nfin=3
MM3 net30 A2 net29 VSS nmos_rvt w=81.0n l=20n nfin=3
MM1 Y C net020 VDD pmos_rvt w=81.0n l=20n nfin=3
MM9 net020 B net23 VDD pmos_rvt w=81.0n l=20n nfin=3
MM10 net23 A3 VDD VDD pmos_rvt w=81.0n l=20n nfin=3
MM7 net23 A2 VDD VDD pmos_rvt w=81.0n l=20n nfin=3
MM6 net23 A1 VDD VDD pmos_rvt w=81.0n l=20n nfin=3
.ENDS

.SUBCKT AOI31xp33_ASAP7_75t_R A1 A2 A3 B VDD VSS Y
MM5 Y B VSS VSS nmos_rvt w=54.0n l=20n nfin=2
MM4 net29 A3 VSS VSS nmos_rvt w=81.0n l=20n nfin=3
MM2 Y A1 net30 VSS nmos_rvt w=81.0n l=20n nfin=3
MM3 net30 A2 net29 VSS nmos_rvt w=81.0n l=20n nfin=3
MM9 Y B net23 VDD pmos_rvt w=54.0n l=20n nfin=2
MM10 net23 A3 VDD VDD pmos_rvt w=54.0n l=20n nfin=2
MM7 net23 A2 VDD VDD pmos_rvt w=54.0n l=20n nfin=2
MM6 net23 A1 VDD VDD pmos_rvt w=54.0n l=20n nfin=2
.ENDS

.SUBCKT AOI31xp67_ASAP7_75t_R A1 A2 A3 B VDD VSS Y
MM5 Y B VSS VSS nmos_rvt w=54.0n l=20n nfin=2
MM4 net29 A3 VSS VSS nmos_rvt w=162.00n l=20n nfin=6
MM2 Y A1 net30 VSS nmos_rvt w=162.00n l=20n nfin=6
MM3 net30 A2 net29 VSS nmos_rvt w=162.00n l=20n nfin=6
MM9 Y B net23 VDD pmos_rvt w=162.00n l=20n nfin=6
MM10 net23 A3 VDD VDD pmos_rvt w=162.00n l=20n nfin=6
MM7 net23 A2 VDD VDD pmos_rvt w=162.00n l=20n nfin=6
MM6 net23 A1 VDD VDD pmos_rvt w=162.00n l=20n nfin=6
.ENDS

.SUBCKT AOI321xp33_ASAP7_75t_R A1 A2 A3 B1 B2 C VDD VSS Y
MM11 Y B2 net026 VSS nmos_rvt w=54.0n l=20n nfin=2
MM0 Y C VSS VSS nmos_rvt w=54.0n l=20n nfin=2
MM5 net026 B1 VSS VSS nmos_rvt w=54.0n l=20n nfin=2
MM4 net29 A3 VSS VSS nmos_rvt w=81.0n l=20n nfin=3
MM2 Y A1 net30 VSS nmos_rvt w=81.0n l=20n nfin=3
MM3 net30 A2 net29 VSS nmos_rvt w=81.0n l=20n nfin=3
MM8 Y B2 net013 VDD pmos_rvt w=81.0n l=20n nfin=3
MM12 net013 C net23 VDD pmos_rvt w=81.0n l=20n nfin=3
MM9 Y B1 net013 VDD pmos_rvt w=81.0n l=20n nfin=3
MM10 net23 A3 VDD VDD pmos_rvt w=81.0n l=20n nfin=3
MM7 net23 A2 VDD VDD pmos_rvt w=81.0n l=20n nfin=3
MM6 net23 A1 VDD VDD pmos_rvt w=81.0n l=20n nfin=3
.ENDS

.SUBCKT AOI322xp5_ASAP7_75t_R A1 A2 A3 B1 B2 C1 C2 VDD VSS Y
MM6 net50 C2 VSS VSS nmos_rvt w=54.0n l=20n nfin=2
MM5 Y C1 net50 VSS nmos_rvt w=54.0n l=20n nfin=2
MM4 net51 B2 VSS VSS nmos_rvt w=54.0n l=20n nfin=2
MM3 Y B1 net51 VSS nmos_rvt w=54.0n l=20n nfin=2
MM2 net52 A3 VSS VSS nmos_rvt w=81.0n l=20n nfin=3
MM1 net49 A2 net52 VSS nmos_rvt w=81.0n l=20n nfin=3
MM0 Y A1 net49 VSS nmos_rvt w=81.0n l=20n nfin=3
MM13 net53 A3 net27 VDD pmos_rvt w=81.0n l=20n nfin=3
MM12 Y C2 net53 VDD pmos_rvt w=81.0n l=20n nfin=3
MM11 net53 A2 net27 VDD pmos_rvt w=81.0n l=20n nfin=3
MM10 net27 B2 VDD VDD pmos_rvt w=81.0n l=20n nfin=3
MM9 Y C1 net53 VDD pmos_rvt w=81.0n l=20n nfin=3
MM8 net53 A1 net27 VDD pmos_rvt w=81.0n l=20n nfin=3
MM7 net27 B1 VDD VDD pmos_rvt w=81.0n l=20n nfin=3
.ENDS

.SUBCKT AOI32xp33_ASAP7_75t_R A1 A2 A3 B1 B2 VDD VSS Y
MM0 Y A1 net24 VSS nmos_rvt w=81.0n l=20n nfin=3
MM2 net24 A2 net25 VSS nmos_rvt w=81.0n l=20n nfin=3
MM3 net25 A3 VSS VSS nmos_rvt w=81.0n l=20n nfin=3
MM18 net26 B2 VSS VSS nmos_rvt w=54.0n l=20n nfin=2
MM13 Y B1 net26 VSS nmos_rvt w=54.0n l=20n nfin=2
MM1 net10 A2 VDD VDD pmos_rvt w=54.0n l=20n nfin=2
MM4 net10 A3 VDD VDD pmos_rvt w=54.0n l=20n nfin=2
MM5 net10 A1 VDD VDD pmos_rvt w=54.0n l=20n nfin=2
MM15 Y B2 net10 VDD pmos_rvt w=54.0n l=20n nfin=2
MM14 Y B1 net10 VDD pmos_rvt w=54.0n l=20n nfin=2
.ENDS

.SUBCKT AOI331xp33_ASAP7_75t_R A1 A2 A3 B1 B2 B3 C1 VDD VSS Y
MM17 Y C1 VSS VSS nmos_rvt w=81.0n l=20n nfin=3
MM12 Y B1 net063 VSS nmos_rvt w=81.0n l=20n nfin=3
MM11 net063 B2 net064 VSS nmos_rvt w=81.0n l=20n nfin=3
MM10 net064 B3 VSS VSS nmos_rvt w=81.0n l=20n nfin=3
MM3 net25 A3 VSS VSS nmos_rvt w=81.0n l=20n nfin=3
MM14 Y A1 net26 VSS nmos_rvt w=81.0n l=20n nfin=3
MM2 net26 A2 net25 VSS nmos_rvt w=81.0n l=20n nfin=3
MM9 net031 A1 VDD VDD pmos_rvt w=81.0n l=20n nfin=3
MM8 net031 A2 VDD VDD pmos_rvt w=81.0n l=20n nfin=3
MM7 net031 A3 VDD VDD pmos_rvt w=81.0n l=20n nfin=3
MM6 net030 B1 net031 VDD pmos_rvt w=81.0n l=20n nfin=3
MM1 Y C1 net030 VDD pmos_rvt w=81.0n l=20n nfin=3
MM5 net030 B2 net031 VDD pmos_rvt w=81.0n l=20n nfin=3
MM4 net030 B3 net031 VDD pmos_rvt w=81.0n l=20n nfin=3
.ENDS

.SUBCKT AOI332xp33_ASAP7_75t_R A1 A2 A3 B1 B2 B3 C1 C2 VDD VSS Y
MM17 Y C1 net061 VSS nmos_rvt w=81.0n l=20n nfin=3
MM16 net061 C2 VSS VSS nmos_rvt w=81.0n l=20n nfin=3
MM12 Y B1 net063 VSS nmos_rvt w=81.0n l=20n nfin=3
MM11 net063 B2 net064 VSS nmos_rvt w=81.0n l=20n nfin=3
MM10 net064 B3 VSS VSS nmos_rvt w=81.0n l=20n nfin=3
MM3 net25 A3 VSS VSS nmos_rvt w=81.0n l=20n nfin=3
MM14 Y A1 net26 VSS nmos_rvt w=81.0n l=20n nfin=3
MM2 net26 A2 net25 VSS nmos_rvt w=81.0n l=20n nfin=3
MM9 net031 A1 VDD VDD pmos_rvt w=81.0n l=20n nfin=3
MM8 net031 A2 VDD VDD pmos_rvt w=81.0n l=20n nfin=3
MM7 net031 A3 VDD VDD pmos_rvt w=81.0n l=20n nfin=3
MM6 net030 B1 net031 VDD pmos_rvt w=81.0n l=20n nfin=3
MM1 Y C1 net030 VDD pmos_rvt w=81.0n l=20n nfin=3
MM5 net030 B2 net031 VDD pmos_rvt w=81.0n l=20n nfin=3
MM4 net030 B3 net031 VDD pmos_rvt w=81.0n l=20n nfin=3
MM0 Y C2 net030 VDD pmos_rvt w=81.0n l=20n nfin=3
.ENDS

.SUBCKT AOI333xp33_ASAP7_75t_R A1 A2 A3 B1 B2 B3 C1 C2 C3 VDD VSS Y
MM17 Y C1 net061 VSS nmos_rvt w=81.0n l=20n nfin=3
MM16 net061 C2 net062 VSS nmos_rvt w=81.0n l=20n nfin=3
MM13 net062 C3 VSS VSS nmos_rvt w=81.0n l=20n nfin=3
MM12 Y B1 net063 VSS nmos_rvt w=81.0n l=20n nfin=3
MM11 net063 B2 net064 VSS nmos_rvt w=81.0n l=20n nfin=3
MM10 net064 B3 VSS VSS nmos_rvt w=81.0n l=20n nfin=3
MM3 net25 A3 VSS VSS nmos_rvt w=81.0n l=20n nfin=3
MM14 Y A1 net26 VSS nmos_rvt w=81.0n l=20n nfin=3
MM2 net26 A2 net25 VSS nmos_rvt w=81.0n l=20n nfin=3
MM9 net031 C1 VDD VDD pmos_rvt w=81.0n l=20n nfin=3
MM8 net031 C2 VDD VDD pmos_rvt w=81.0n l=20n nfin=3
MM7 net031 C3 VDD VDD pmos_rvt w=81.0n l=20n nfin=3
MM6 net030 B1 net031 VDD pmos_rvt w=81.0n l=20n nfin=3
MM1 Y A1 net030 VDD pmos_rvt w=81.0n l=20n nfin=3
MM5 net030 B2 net031 VDD pmos_rvt w=81.0n l=20n nfin=3
MM15 Y A3 net030 VDD pmos_rvt w=81.0n l=20n nfin=3
MM4 net030 B3 net031 VDD pmos_rvt w=81.0n l=20n nfin=3
MM0 Y A2 net030 VDD pmos_rvt w=81.0n l=20n nfin=3
.ENDS

.SUBCKT AOI33xp33_ASAP7_75t_R A1 A2 A3 B1 B2 B3 VDD VSS Y
MM44 Y B1 net52 VSS nmos_rvt w=81.0n l=20n nfin=3
MM45 net52 B2 net51 VSS nmos_rvt w=81.0n l=20n nfin=3
MM48 net51 B3 VSS VSS nmos_rvt w=81.0n l=20n nfin=3
MM39 Y A3 net54 VSS nmos_rvt w=81.0n l=20n nfin=3
MM46 net54 A2 net53 VSS nmos_rvt w=81.0n l=20n nfin=3
MM47 net53 A1 VSS VSS nmos_rvt w=81.0n l=20n nfin=3
MM33 net015 A3 VDD VDD pmos_rvt w=54.0n l=20n nfin=2
MM35 Y B1 net015 VDD pmos_rvt w=54.0n l=20n nfin=2
MM32 net015 A2 VDD VDD pmos_rvt w=54.0n l=20n nfin=2
MM38 Y B2 net015 VDD pmos_rvt w=54.0n l=20n nfin=2
MM31 net015 A1 VDD VDD pmos_rvt w=54.0n l=20n nfin=2
MM37 Y B3 net015 VDD pmos_rvt w=54.0n l=20n nfin=2
.ENDS

.SUBCKT BUFx10_ASAP7_75t_R A VDD VSS Y
MM0 AN A VDD VDD pmos_rvt w=162.00n l=20n nfin=6
MM1 Y AN VDD VDD pmos_rvt w=810.0n l=20n nfin=30
MM2 AN A VSS VSS nmos_rvt w=162.00n l=20n nfin=6
MM3 Y AN VSS VSS nmos_rvt w=810.0n l=20n nfin=30
.ENDS

.SUBCKT BUFx12_ASAP7_75t_R A VDD VSS Y
M0 N_M0_d A VSS VSS nmos_rvt L=2e-08 W=8.1e-08 nfin=3
M1 N_M0_d A VSS VSS nmos_rvt L=2e-08 W=8.1e-08 nfin=3
M2 Y N_M0_d VSS VSS nmos_rvt L=2e-08 W=8.1e-08 nfin=3
M3 Y N_M0_d VSS VSS nmos_rvt L=2e-08 W=8.1e-08 nfin=3
M4 Y N_M0_d VSS VSS nmos_rvt L=2e-08 W=8.1e-08 nfin=3
M5 Y N_M0_d VSS VSS nmos_rvt L=2e-08 W=8.1e-08 nfin=3
M6 Y N_M0_d VSS VSS nmos_rvt L=2e-08 W=8.1e-08 nfin=3
M7 Y N_M0_d VSS VSS nmos_rvt L=2e-08 W=8.1e-08 nfin=3
M8 Y N_M0_d VSS VSS nmos_rvt L=2e-08 W=8.1e-08 nfin=3
M9 Y N_M0_d VSS VSS nmos_rvt L=2e-08 W=8.1e-08 nfin=3
M10 Y N_M0_d VSS VSS nmos_rvt L=2e-08 W=8.1e-08 nfin=3
M11 Y N_M0_d VSS VSS nmos_rvt L=2e-08 W=8.1e-08 nfin=3
M12 Y N_M0_d VSS VSS nmos_rvt L=2e-08 W=8.1e-08 nfin=3
M13 Y N_M0_d VSS VSS nmos_rvt L=2e-08 W=8.1e-08 nfin=3
M14 N_M0_d A VDD VDD pmos_rvt L=2e-08 W=8.1e-08 nfin=3
M15 N_M0_d A VDD VDD pmos_rvt L=2e-08 W=8.1e-08 nfin=3
M16 Y N_M0_d VDD VDD pmos_rvt L=2e-08 W=8.1e-08 nfin=3
M17 Y N_M0_d VDD VDD pmos_rvt L=2e-08 W=8.1e-08 nfin=3
M18 Y N_M0_d VDD VDD pmos_rvt L=2e-08 W=8.1e-08 nfin=3
M19 Y N_M0_d VDD VDD pmos_rvt L=2e-08 W=8.1e-08 nfin=3
M20 Y N_M0_d VDD VDD pmos_rvt L=2e-08 W=8.1e-08 nfin=3
M21 Y N_M0_d VDD VDD pmos_rvt L=2e-08 W=8.1e-08 nfin=3
M22 Y N_M0_d VDD VDD pmos_rvt L=2e-08 W=8.1e-08 nfin=3
M23 Y N_M0_d VDD VDD pmos_rvt L=2e-08 W=8.1e-08 nfin=3
M24 Y N_M0_d VDD VDD pmos_rvt L=2e-08 W=8.1e-08 nfin=3
M25 Y N_M0_d VDD VDD pmos_rvt L=2e-08 W=8.1e-08 nfin=3
M26 Y N_M0_d VDD VDD pmos_rvt L=2e-08 W=8.1e-08 nfin=3
M27 Y N_M0_d VDD VDD pmos_rvt L=2e-08 W=8.1e-08 nfin=3
.ENDS

.SUBCKT BUFx12f_ASAP7_75t_R A VDD VSS Y
MM1 Y AN VDD VDD pmos_rvt w=972.00n l=20n nfin=36
MM0 AN A VDD VDD pmos_rvt w=324.00n l=20n nfin=12
MM3 Y AN VSS VSS nmos_rvt w=972.00n l=20n nfin=36
MM2 AN A VSS VSS nmos_rvt w=324.00n l=20n nfin=12
.ENDS

.SUBCKT BUFx16f_ASAP7_75t_R A VDD VSS Y
MM1 Y AN VDD VDD pmos_rvt w=1.296u l=20n nfin=48
MM0 AN A VDD VDD pmos_rvt w=324.00n l=20n nfin=12
MM3 Y AN VSS VSS nmos_rvt w=1.296u l=20n nfin=48
MM2 AN A VSS VSS nmos_rvt w=324.00n l=20n nfin=12
.ENDS

.SUBCKT BUFx24_ASAP7_75t_R A VDD VSS Y
MM1 Y AN VDD VDD pmos_rvt w=1.944u l=20n nfin=72
MM0 AN A VDD VDD pmos_rvt w=324.00n l=20n nfin=12
MM3 Y AN VSS VSS nmos_rvt w=1.944u l=20n nfin=72
MM2 AN A VSS VSS nmos_rvt w=324.00n l=20n nfin=12
.ENDS

.SUBCKT BUFx2_ASAP7_75t_R A VDD VSS Y
M0 VSS A N_M0_s VSS nmos_rvt L=2e-08 W=5.4e-08 nfin=2
M1 Y N_M0_s VSS VSS nmos_rvt L=2e-08 W=8.1e-08 nfin=3
M2 Y N_M0_s VSS VSS nmos_rvt L=2e-08 W=8.1e-08 nfin=3
M3 VDD A N_M0_s VDD pmos_rvt L=2e-08 W=5.4e-08 nfin=2
M4 Y N_M0_s VDD VDD pmos_rvt L=2e-08 W=8.1e-08 nfin=3
M5 Y N_M0_s VDD VDD pmos_rvt L=2e-08 W=8.1e-08 nfin=3
.ENDS

.SUBCKT BUFx3_ASAP7_75t_R A VDD VSS Y
M0 VSS A N_M0_s VSS nmos_rvt L=2e-08 W=8.1e-08 nfin=3
M1 Y N_M0_s VSS VSS nmos_rvt L=2e-08 W=8.1e-08 nfin=3
M2 Y N_M0_s VSS VSS nmos_rvt L=2e-08 W=8.1e-08 nfin=3
M3 Y N_M0_s VSS VSS nmos_rvt L=2e-08 W=8.1e-08 nfin=3
M4 VDD A N_M0_s VDD pmos_rvt L=2e-08 W=8.1e-08 nfin=3
M5 Y N_M0_s VDD VDD pmos_rvt L=2e-08 W=8.1e-08 nfin=3
M6 Y N_M0_s VDD VDD pmos_rvt L=2e-08 W=8.1e-08 nfin=3
M7 Y N_M0_s VDD VDD pmos_rvt L=2e-08 W=8.1e-08 nfin=3
.ENDS

.SUBCKT BUFx4_ASAP7_75t_R A VDD VSS Y
M0 VSS A N_M0_s VSS nmos_rvt L=2e-08 W=5.4e-08 nfin=2
M1 Y N_M0_s VSS VSS nmos_rvt L=2e-08 W=8.1e-08 nfin=3
M2 Y N_M0_s VSS VSS nmos_rvt L=2e-08 W=8.1e-08 nfin=3
M3 Y N_M0_s VSS VSS nmos_rvt L=2e-08 W=8.1e-08 nfin=3
M4 Y N_M0_s VSS VSS nmos_rvt L=2e-08 W=8.1e-08 nfin=3
M5 VDD A N_M0_s VDD pmos_rvt L=2e-08 W=5.4e-08 nfin=2
M6 Y N_M0_s VDD VDD pmos_rvt L=2e-08 W=8.1e-08 nfin=3
M7 Y N_M0_s VDD VDD pmos_rvt L=2e-08 W=8.1e-08 nfin=3
M8 Y N_M0_s VDD VDD pmos_rvt L=2e-08 W=8.1e-08 nfin=3
M9 Y N_M0_s VDD VDD pmos_rvt L=2e-08 W=8.1e-08 nfin=3
.ENDS

.SUBCKT BUFx4f_ASAP7_75t_R A VDD VSS Y
MM1 Y AN VDD VDD pmos_rvt w=324.00n l=20n nfin=12
MM0 AN A VDD VDD pmos_rvt w=108.00n l=20n nfin=4
MM3 Y AN VSS VSS nmos_rvt w=324.00n l=20n nfin=12
MM2 AN A VSS VSS nmos_rvt w=108.00n l=20n nfin=4
.ENDS

.SUBCKT BUFx5_ASAP7_75t_R A VDD VSS Y
MM1 Y AN VDD VDD pmos_rvt w=405.00n l=20n nfin=15
MM0 AN A VDD VDD pmos_rvt w=81.0n l=20n nfin=3
MM3 Y AN VSS VSS nmos_rvt w=405.00n l=20n nfin=15
MM2 AN A VSS VSS nmos_rvt w=81.0n l=20n nfin=3
.ENDS

.SUBCKT BUFx6f_ASAP7_75t_R A VDD VSS Y
MM1 Y AN VDD VDD pmos_rvt w=486.00n l=20n nfin=18
MM0 AN A VDD VDD pmos_rvt w=162.00n l=20n nfin=6
MM3 Y AN VSS VSS nmos_rvt w=486.00n l=20n nfin=18
MM2 AN A VSS VSS nmos_rvt w=162.00n l=20n nfin=6
.ENDS

.SUBCKT BUFx8_ASAP7_75t_R A VDD VSS Y
MM0 AN A VDD VDD pmos_rvt w=108.00n l=20n nfin=4
MM1 Y AN VDD VDD pmos_rvt w=648.00n l=20n nfin=24
MM2 AN A VSS VSS nmos_rvt w=108.00n l=20n nfin=4
MM3 Y AN VSS VSS nmos_rvt w=648.00n l=20n nfin=24
.ENDS

.SUBCKT CKINVDCx10_ASAP7_75t_R A VDD VSS Y
MM13 net067 net063 VSS VSS nmos_rvt w=162.00n l=20n nfin=6
MM12 net067 net067 VSS VSS nmos_rvt w=162.00n l=20n nfin=6
MM9 net066 net061 VSS VSS nmos_rvt w=162.00n l=20n nfin=6
MM8 net066 net066 VSS VSS nmos_rvt w=162.00n l=20n nfin=6
MM0 Y A VSS VSS nmos_rvt w=810.0n l=20n nfin=30
MM2 net030 net030 VSS VSS nmos_rvt w=162.00n l=20n nfin=6
MM3 net030 net029 VSS VSS nmos_rvt w=162.00n l=20n nfin=6
MM11 net063 net063 VDD VDD pmos_rvt w=162.00n l=20n nfin=6
MM10 net063 net067 VDD VDD pmos_rvt w=162.00n l=20n nfin=6
MM7 net061 net061 VDD VDD pmos_rvt w=162.00n l=20n nfin=6
MM6 net061 net066 VDD VDD pmos_rvt w=162.00n l=20n nfin=6
MM5 net029 net029 VDD VDD pmos_rvt w=162.00n l=20n nfin=6
MM4 net029 net030 VDD VDD pmos_rvt w=162.00n l=20n nfin=6
MM1 Y A VDD VDD pmos_rvt w=810.0n l=20n nfin=30
.ENDS

.SUBCKT CKINVDCx11_ASAP7_75t_R A VDD VSS Y
MM13 net067 net063 VSS VSS nmos_rvt w=162.00n l=20n nfin=6
MM12 net067 net067 VSS VSS nmos_rvt w=162.00n l=20n nfin=6
MM9 net066 net061 VSS VSS nmos_rvt w=162.00n l=20n nfin=6
MM8 net066 net066 VSS VSS nmos_rvt w=162.00n l=20n nfin=6
MM0 Y A VSS VSS nmos_rvt w=891.00n l=20n nfin=33
MM2 net030 net030 VSS VSS nmos_rvt w=162.00n l=20n nfin=6
MM3 net030 net029 VSS VSS nmos_rvt w=162.00n l=20n nfin=6
MM11 net063 net063 VDD VDD pmos_rvt w=162.00n l=20n nfin=6
MM10 net063 net067 VDD VDD pmos_rvt w=162.00n l=20n nfin=6
MM7 net061 net061 VDD VDD pmos_rvt w=162.00n l=20n nfin=6
MM6 net061 net066 VDD VDD pmos_rvt w=162.00n l=20n nfin=6
MM5 net029 net029 VDD VDD pmos_rvt w=162.00n l=20n nfin=6
MM4 net029 net030 VDD VDD pmos_rvt w=162.00n l=20n nfin=6
MM1 Y A VDD VDD pmos_rvt w=891.00n l=20n nfin=33
.ENDS

.SUBCKT CKINVDCx12_ASAP7_75t_R A VDD VSS Y
MM13 net067 net063 VSS VSS nmos_rvt w=162.00n l=20n nfin=6
MM12 net067 net067 VSS VSS nmos_rvt w=162.00n l=20n nfin=6
MM9 net066 net061 VSS VSS nmos_rvt w=162.00n l=20n nfin=6
MM8 net066 net066 VSS VSS nmos_rvt w=162.00n l=20n nfin=6
MM0 Y A VSS VSS nmos_rvt w=972.00n l=20n nfin=36
MM2 net030 net030 VSS VSS nmos_rvt w=162.00n l=20n nfin=6
MM3 net030 net029 VSS VSS nmos_rvt w=162.00n l=20n nfin=6
MM11 net063 net063 VDD VDD pmos_rvt w=162.00n l=20n nfin=6
MM10 net063 net067 VDD VDD pmos_rvt w=162.00n l=20n nfin=6
MM7 net061 net061 VDD VDD pmos_rvt w=162.00n l=20n nfin=6
MM6 net061 net066 VDD VDD pmos_rvt w=162.00n l=20n nfin=6
MM5 net029 net029 VDD VDD pmos_rvt w=162.00n l=20n nfin=6
MM4 net029 net030 VDD VDD pmos_rvt w=162.00n l=20n nfin=6
MM1 Y A VDD VDD pmos_rvt w=972.00n l=20n nfin=36
.ENDS

.SUBCKT CKINVDCx14_ASAP7_75t_R A VDD VSS Y
MM13 net067 net063 VSS VSS nmos_rvt w=162.00n l=20n nfin=6
MM12 net067 net067 VSS VSS nmos_rvt w=162.00n l=20n nfin=6
MM9 net066 net061 VSS VSS nmos_rvt w=162.00n l=20n nfin=6
MM8 net066 net066 VSS VSS nmos_rvt w=162.00n l=20n nfin=6
MM0 Y A VSS VSS nmos_rvt w=1.134u l=20n nfin=42
MM2 net030 net030 VSS VSS nmos_rvt w=162.00n l=20n nfin=6
MM3 net030 net029 VSS VSS nmos_rvt w=162.00n l=20n nfin=6
MM11 net063 net063 VDD VDD pmos_rvt w=162.00n l=20n nfin=6
MM10 net063 net067 VDD VDD pmos_rvt w=162.00n l=20n nfin=6
MM7 net061 net061 VDD VDD pmos_rvt w=162.00n l=20n nfin=6
MM6 net061 net066 VDD VDD pmos_rvt w=162.00n l=20n nfin=6
MM5 net029 net029 VDD VDD pmos_rvt w=162.00n l=20n nfin=6
MM4 net029 net030 VDD VDD pmos_rvt w=162.00n l=20n nfin=6
MM1 Y A VDD VDD pmos_rvt w=1.134u l=20n nfin=42
.ENDS

.SUBCKT CKINVDCx16_ASAP7_75t_R A VDD VSS Y
MM13 net067 net063 VSS VSS nmos_rvt w=162.00n l=20n nfin=6
MM12 net067 net067 VSS VSS nmos_rvt w=162.00n l=20n nfin=6
MM9 net066 net061 VSS VSS nmos_rvt w=162.00n l=20n nfin=6
MM8 net066 net066 VSS VSS nmos_rvt w=162.00n l=20n nfin=6
MM0 Y A VSS VSS nmos_rvt w=1.296u l=20n nfin=48
MM2 net030 net030 VSS VSS nmos_rvt w=162.00n l=20n nfin=6
MM3 net030 net029 VSS VSS nmos_rvt w=162.00n l=20n nfin=6
MM11 net063 net063 VDD VDD pmos_rvt w=162.00n l=20n nfin=6
MM10 net063 net067 VDD VDD pmos_rvt w=162.00n l=20n nfin=6
MM7 net061 net061 VDD VDD pmos_rvt w=162.00n l=20n nfin=6
MM6 net061 net066 VDD VDD pmos_rvt w=162.00n l=20n nfin=6
MM5 net029 net029 VDD VDD pmos_rvt w=162.00n l=20n nfin=6
MM4 net029 net030 VDD VDD pmos_rvt w=162.00n l=20n nfin=6
MM1 Y A VDD VDD pmos_rvt w=1.296u l=20n nfin=48
.ENDS

.SUBCKT CKINVDCx20_ASAP7_75t_R A VDD VSS Y
MM15 net056 net056 VSS VSS nmos_rvt w=162.00n l=20n nfin=6
MM14 net056 net049 VSS VSS nmos_rvt w=162.00n l=20n nfin=6
MM13 net067 net063 VSS VSS nmos_rvt w=162.00n l=20n nfin=6
MM12 net067 net067 VSS VSS nmos_rvt w=162.00n l=20n nfin=6
MM9 net066 net061 VSS VSS nmos_rvt w=162.00n l=20n nfin=6
MM8 net066 net066 VSS VSS nmos_rvt w=162.00n l=20n nfin=6
MM0 Y A VSS VSS nmos_rvt w=1.62u l=20n nfin=60
MM2 net030 net030 VSS VSS nmos_rvt w=162.00n l=20n nfin=6
MM3 net030 net029 VSS VSS nmos_rvt w=162.00n l=20n nfin=6
MM17 net049 net056 VDD VDD pmos_rvt w=162.00n l=20n nfin=6
MM16 net049 net049 VDD VDD pmos_rvt w=162.00n l=20n nfin=6
MM11 net063 net063 VDD VDD pmos_rvt w=162.00n l=20n nfin=6
MM10 net063 net067 VDD VDD pmos_rvt w=162.00n l=20n nfin=6
MM7 net061 net061 VDD VDD pmos_rvt w=162.00n l=20n nfin=6
MM6 net061 net066 VDD VDD pmos_rvt w=162.00n l=20n nfin=6
MM5 net029 net029 VDD VDD pmos_rvt w=162.00n l=20n nfin=6
MM4 net029 net030 VDD VDD pmos_rvt w=162.00n l=20n nfin=6
MM1 Y A VDD VDD pmos_rvt w=1.62u l=20n nfin=60
.ENDS

.SUBCKT CKINVDCx5p33_ASAP7_75t_R A VDD VSS Y
MM13 net067 net063 VSS VSS nmos_rvt w=162.00n l=20n nfin=6
MM12 net067 net067 VSS VSS nmos_rvt w=162.00n l=20n nfin=6
MM9 net066 net061 VSS VSS nmos_rvt w=162.00n l=20n nfin=6
MM8 net066 net066 VSS VSS nmos_rvt w=162.00n l=20n nfin=6
MM0 Y A VSS VSS nmos_rvt w=432.00n l=20n nfin=16
MM2 net030 net030 VSS VSS nmos_rvt w=162.00n l=20n nfin=6
MM3 net030 net029 VSS VSS nmos_rvt w=162.00n l=20n nfin=6
MM11 net063 net063 VDD VDD pmos_rvt w=162.00n l=20n nfin=6
MM10 net063 net067 VDD VDD pmos_rvt w=162.00n l=20n nfin=6
MM7 net061 net061 VDD VDD pmos_rvt w=162.00n l=20n nfin=6
MM6 net061 net066 VDD VDD pmos_rvt w=162.00n l=20n nfin=6
MM5 net029 net029 VDD VDD pmos_rvt w=162.00n l=20n nfin=6
MM4 net029 net030 VDD VDD pmos_rvt w=162.00n l=20n nfin=6
MM1 Y A VDD VDD pmos_rvt w=432.00n l=20n nfin=16
.ENDS

.SUBCKT CKINVDCx6p67_ASAP7_75t_R A VDD VSS Y
MM13 net067 net063 VSS VSS nmos_rvt w=162.00n l=20n nfin=6
MM12 net067 net067 VSS VSS nmos_rvt w=162.00n l=20n nfin=6
MM9 net066 net061 VSS VSS nmos_rvt w=162.00n l=20n nfin=6
MM8 net066 net066 VSS VSS nmos_rvt w=162.00n l=20n nfin=6
MM0 Y A VSS VSS nmos_rvt w=540.0n l=20n nfin=20
MM2 net030 net030 VSS VSS nmos_rvt w=162.00n l=20n nfin=6
MM3 net030 net029 VSS VSS nmos_rvt w=162.00n l=20n nfin=6
MM11 net063 net063 VDD VDD pmos_rvt w=162.00n l=20n nfin=6
MM10 net063 net067 VDD VDD pmos_rvt w=162.00n l=20n nfin=6
MM7 net061 net061 VDD VDD pmos_rvt w=162.00n l=20n nfin=6
MM6 net061 net066 VDD VDD pmos_rvt w=162.00n l=20n nfin=6
MM5 net029 net029 VDD VDD pmos_rvt w=162.00n l=20n nfin=6
MM4 net029 net030 VDD VDD pmos_rvt w=162.00n l=20n nfin=6
MM1 Y A VDD VDD pmos_rvt w=540.0n l=20n nfin=20
.ENDS

.SUBCKT CKINVDCx8_ASAP7_75t_R A VDD VSS Y
MM13 net067 net063 VSS VSS nmos_rvt w=162.00n l=20n nfin=6
MM12 net067 net067 VSS VSS nmos_rvt w=162.00n l=20n nfin=6
MM9 net066 net061 VSS VSS nmos_rvt w=162.00n l=20n nfin=6
MM8 net066 net066 VSS VSS nmos_rvt w=162.00n l=20n nfin=6
MM0 Y A VSS VSS nmos_rvt w=648.00n l=20n nfin=24
MM2 net030 net030 VSS VSS nmos_rvt w=162.00n l=20n nfin=6
MM3 net030 net029 VSS VSS nmos_rvt w=162.00n l=20n nfin=6
MM11 net063 net063 VDD VDD pmos_rvt w=162.00n l=20n nfin=6
MM10 net063 net067 VDD VDD pmos_rvt w=162.00n l=20n nfin=6
MM7 net061 net061 VDD VDD pmos_rvt w=162.00n l=20n nfin=6
MM6 net061 net066 VDD VDD pmos_rvt w=162.00n l=20n nfin=6
MM5 net029 net029 VDD VDD pmos_rvt w=162.00n l=20n nfin=6
MM4 net029 net030 VDD VDD pmos_rvt w=162.00n l=20n nfin=6
MM1 Y A VDD VDD pmos_rvt w=648.00n l=20n nfin=24
.ENDS

.SUBCKT CKINVDCx9p33_ASAP7_75t_R A VDD VSS Y
MM13 net067 net063 VSS VSS nmos_rvt w=162.00n l=20n nfin=6
MM12 net067 net067 VSS VSS nmos_rvt w=162.00n l=20n nfin=6
MM9 net066 net061 VSS VSS nmos_rvt w=162.00n l=20n nfin=6
MM8 net066 net066 VSS VSS nmos_rvt w=162.00n l=20n nfin=6
MM0 Y A VSS VSS nmos_rvt w=756.00n l=20n nfin=28
MM2 net030 net030 VSS VSS nmos_rvt w=162.00n l=20n nfin=6
MM3 net030 net029 VSS VSS nmos_rvt w=162.00n l=20n nfin=6
MM11 net063 net063 VDD VDD pmos_rvt w=162.00n l=20n nfin=6
MM10 net063 net067 VDD VDD pmos_rvt w=162.00n l=20n nfin=6
MM7 net061 net061 VDD VDD pmos_rvt w=162.00n l=20n nfin=6
MM6 net061 net066 VDD VDD pmos_rvt w=162.00n l=20n nfin=6
MM5 net029 net029 VDD VDD pmos_rvt w=162.00n l=20n nfin=6
MM4 net029 net030 VDD VDD pmos_rvt w=162.00n l=20n nfin=6
MM1 Y A VDD VDD pmos_rvt w=756.00n l=20n nfin=28
.ENDS

.SUBCKT DECAPx10_ASAP7_75t_R VDD VSS
M0 VSS N_M0_g N_M0_s VSS nmos_rvt L=2e-08 W=8.1e-08 nfin=3
M1 VSS N_M0_g N_M0_s VSS nmos_rvt L=2e-08 W=8.1e-08 nfin=3
M2 VSS N_M0_g N_M0_s VSS nmos_rvt L=2e-08 W=8.1e-08 nfin=3
M3 VSS N_M0_g N_M0_s VSS nmos_rvt L=2e-08 W=8.1e-08 nfin=3
M4 VSS N_M0_g N_M0_s VSS nmos_rvt L=2e-08 W=8.1e-08 nfin=3
M5 VSS N_M0_g N_M0_s VSS nmos_rvt L=2e-08 W=8.1e-08 nfin=3
M6 VSS N_M0_g N_M0_s VSS nmos_rvt L=2e-08 W=8.1e-08 nfin=3
M7 VSS N_M0_g N_M0_s VSS nmos_rvt L=2e-08 W=8.1e-08 nfin=3
M8 VSS N_M0_g N_M0_s VSS nmos_rvt L=2e-08 W=8.1e-08 nfin=3
M9 VSS N_M0_g N_M0_s VSS nmos_rvt L=2e-08 W=8.1e-08 nfin=3
M10 VDD N_M0_s N_M0_g VDD pmos_rvt L=2e-08 W=8.1e-08 nfin=3
M11 VDD N_M0_s N_M0_g VDD pmos_rvt L=2e-08 W=8.1e-08 nfin=3
M12 VDD N_M0_s N_M0_g VDD pmos_rvt L=2e-08 W=8.1e-08 nfin=3
M13 VDD N_M0_s N_M0_g VDD pmos_rvt L=2e-08 W=8.1e-08 nfin=3
M14 VDD N_M0_s N_M0_g VDD pmos_rvt L=2e-08 W=8.1e-08 nfin=3
M15 VDD N_M0_s N_M0_g VDD pmos_rvt L=2e-08 W=8.1e-08 nfin=3
M16 VDD N_M0_s N_M0_g VDD pmos_rvt L=2e-08 W=8.1e-08 nfin=3
M17 VDD N_M0_s N_M0_g VDD pmos_rvt L=2e-08 W=8.1e-08 nfin=3
M18 VDD N_M0_s N_M0_g VDD pmos_rvt L=2e-08 W=8.1e-08 nfin=3
M19 VDD N_M0_s N_M0_g VDD pmos_rvt L=2e-08 W=8.1e-08 nfin=3
.ENDS

.SUBCKT DECAPx1_ASAP7_75t_R VDD VSS
M0 VSS N_M0_g N_M0_s VSS nmos_rvt L=2e-08 W=8.1e-08 nfin=3
M1 N_M0_g N_M0_s VDD VDD pmos_rvt L=2e-08 W=8.1e-08 nfin=3
.ENDS

.SUBCKT DECAPx2_ASAP7_75t_R VDD VSS
M0 VSS N_M0_g N_M0_s VSS nmos_rvt L=2e-08 W=8.1e-08 nfin=3
M1 VSS N_M0_g N_M0_s VSS nmos_rvt L=2e-08 W=8.1e-08 nfin=3
M2 VDD N_M0_s N_M0_g VDD pmos_rvt L=2e-08 W=8.1e-08 nfin=3
M3 VDD N_M0_s N_M0_g VDD pmos_rvt L=2e-08 W=8.1e-08 nfin=3
.ENDS

.SUBCKT DECAPx2b_ASAP7_75t_R VDD VSS
MM2 net011 net012 VSS VSS nmos_rvt w=162.00n l=20n nfin=6
MM0 net011 net011 VSS VSS nmos_rvt w=162.00n l=20n nfin=6
MM1 net012 net011 VDD VDD pmos_rvt w=162.00n l=20n nfin=6
MM3 net012 net012 VDD VDD pmos_rvt w=162.00n l=20n nfin=6
.ENDS

.SUBCKT DECAPx4_ASAP7_75t_R VDD VSS
M0 VSS N_M0_g N_M0_s VSS nmos_rvt L=2e-08 W=8.1e-08 nfin=3
M1 VSS N_M0_g N_M0_s VSS nmos_rvt L=2e-08 W=8.1e-08 nfin=3
M2 VSS N_M0_g N_M0_s VSS nmos_rvt L=2e-08 W=8.1e-08 nfin=3
M3 VSS N_M0_g N_M0_s VSS nmos_rvt L=2e-08 W=8.1e-08 nfin=3
M4 VDD N_M0_s N_M0_g VDD pmos_rvt L=2e-08 W=8.1e-08 nfin=3
M5 VDD N_M0_s N_M0_g VDD pmos_rvt L=2e-08 W=8.1e-08 nfin=3
M6 VDD N_M0_s N_M0_g VDD pmos_rvt L=2e-08 W=8.1e-08 nfin=3
M7 VDD N_M0_s N_M0_g VDD pmos_rvt L=2e-08 W=8.1e-08 nfin=3
.ENDS

.SUBCKT DECAPx6_ASAP7_75t_R VDD VSS
M0 VSS N_M0_g N_M0_s VSS nmos_rvt L=2e-08 W=8.1e-08 nfin=3
M1 VSS N_M0_g N_M0_s VSS nmos_rvt L=2e-08 W=8.1e-08 nfin=3
M2 VSS N_M0_g N_M0_s VSS nmos_rvt L=2e-08 W=8.1e-08 nfin=3
M3 VSS N_M0_g N_M0_s VSS nmos_rvt L=2e-08 W=8.1e-08 nfin=3
M4 VSS N_M0_g N_M0_s VSS nmos_rvt L=2e-08 W=8.1e-08 nfin=3
M5 VSS N_M0_g N_M0_s VSS nmos_rvt L=2e-08 W=8.1e-08 nfin=3
M6 VDD N_M0_s N_M0_g VDD pmos_rvt L=2e-08 W=8.1e-08 nfin=3
M7 VDD N_M0_s N_M0_g VDD pmos_rvt L=2e-08 W=8.1e-08 nfin=3
M8 VDD N_M0_s N_M0_g VDD pmos_rvt L=2e-08 W=8.1e-08 nfin=3
M9 VDD N_M0_s N_M0_g VDD pmos_rvt L=2e-08 W=8.1e-08 nfin=3
M10 VDD N_M0_s N_M0_g VDD pmos_rvt L=2e-08 W=8.1e-08 nfin=3
M11 VDD N_M0_s N_M0_g VDD pmos_rvt L=2e-08 W=8.1e-08 nfin=3
.ENDS

.SUBCKT DFFASRHQNx1_ASAP7_75t_R CLK D QN RESETn SETn VDD VSS
MM20 clkb CLK VSS VSS nmos_rvt w=54.0n l=20n nfin=2
MM23 clkn clkb VSS VSS nmos_rvt w=54.0n l=20n nfin=2
MM24 QN SH VSS VSS nmos_rvt w=81.0n l=20n nfin=3
MM12 MS clkn SH VSS nmos_rvt w=27.0n l=20n nfin=1
MM4 MH clkb pd1 VSS nmos_rvt w=81.0n l=20n nfin=3
MM7 net55 MH MS VSS nmos_rvt w=54.0n l=20n nfin=2
MM15 net54 SH SS VSS nmos_rvt w=54.0n l=20n nfin=2
MM5 pd1 D VSS VSS nmos_rvt w=81.0n l=20n nfin=3
MM46 VSS SETn net55 VSS nmos_rvt w=54.0n l=20n nfin=2
MM27 VSS RESETn net54 VSS nmos_rvt w=54.0n l=20n nfin=2
MM9 MH clkn net59 VSS nmos_rvt w=27.0n l=20n nfin=1
MM28 SH clkb net57 VSS nmos_rvt w=54.0n l=20n nfin=2
MM0 net58 MS net59 VSS nmos_rvt w=27.0n l=20n nfin=1
MM18 net56 SS net57 VSS nmos_rvt w=54.0n l=20n nfin=2
MM2 VSS RESETn net58 VSS nmos_rvt w=27.0n l=20n nfin=1
MM14 VSS SETn net56 VSS nmos_rvt w=54.0n l=20n nfin=2
MM21 clkb CLK VDD VDD pmos_rvt w=54.0n l=20n nfin=2
MM22 clkn clkb VDD VDD pmos_rvt w=54.0n l=20n nfin=2
MM25 QN SH VDD VDD pmos_rvt w=81.0n l=20n nfin=3
MM13 MS clkb SH VDD pmos_rvt w=27.0n l=20n nfin=1
MM3 pu1 D VDD VDD pmos_rvt w=81.0n l=20n nfin=3
MM47 VDD SETn MS VDD pmos_rvt w=54.0n l=20n nfin=2
MM6 VDD MH MS VDD pmos_rvt w=27.0n l=20n nfin=1
MM26 VDD RESETn SS VDD pmos_rvt w=27.0n l=20n nfin=1
MM19 VDD SH SS VDD pmos_rvt w=27.0n l=20n nfin=1
MM1 MH clkn pu1 VDD pmos_rvt w=81.0n l=20n nfin=3
MM8 VDD MS net19 VDD pmos_rvt w=54.0n l=20n nfin=2
MM11 VDD RESETn net19 VDD pmos_rvt w=54.0n l=20n nfin=2
MM16 VDD SETn net37 VDD pmos_rvt w=54.0n l=20n nfin=2
MM17 VDD SS net37 VDD pmos_rvt w=27.0n l=20n nfin=1
MM10 MH clkb net19 VDD pmos_rvt w=54.0n l=20n nfin=2
MM29 SH clkn net37 VDD pmos_rvt w=54.0n l=20n nfin=2
.ENDS

.SUBCKT DFFHQNx1_ASAP7_75t_R CLK D QN VDD VSS
M0 VSS CLK N_M0_s VSS nmos_rvt L=2e-08 W=5.4e-08 nfin=2
M1 N_M1_d N_M0_s VSS VSS nmos_rvt L=2e-08 W=5.4e-08 nfin=2
M2 N_M2_d D VSS VSS nmos_rvt L=2e-08 W=8.1e-08 nfin=3
M3 N_M3_d N_M0_s N_M2_d VSS nmos_rvt L=2e-08 W=8.1e-08 nfin=3
M4 N_M4_d N_M1_d N_M3_d VSS nmos_rvt L=2e-08 W=2.7e-08 nfin=1
M5 VSS N_M5_g N_M4_d VSS nmos_rvt L=2e-08 W=2.7e-08 nfin=1
M6 N_M5_g N_M3_d VSS VSS nmos_rvt L=2e-08 W=2.7e-08 nfin=1
M7 N_M7_d N_M1_d N_M5_g VSS nmos_rvt L=2e-08 W=2.7e-08 nfin=1
M8 N_M8_d N_M0_s N_M7_d VSS nmos_rvt L=2e-08 W=2.7e-08 nfin=1
M9 VSS N_M9_g N_M8_d VSS nmos_rvt L=2e-08 W=2.7e-08 nfin=1
M10 N_M9_g N_M7_d VSS VSS nmos_rvt L=2e-08 W=2.7e-08 nfin=1
M11 QN N_M7_d VSS VSS nmos_rvt L=2e-08 W=8.1e-08 nfin=3
M12 VDD CLK N_M0_s VDD pmos_rvt L=2e-08 W=5.4e-08 nfin=2
M13 N_M1_d N_M0_s VDD VDD pmos_rvt L=2e-08 W=5.4e-08 nfin=2
M14 N_M14_d D VDD VDD pmos_rvt L=2e-08 W=8.1e-08 nfin=3
M15 N_M3_d N_M1_d N_M14_d VDD pmos_rvt L=2e-08 W=8.1e-08 nfin=3
M16 N_M16_d N_M0_s N_M3_d VDD pmos_rvt L=2e-08 W=2.7e-08 nfin=1
M17 VDD N_M5_g N_M16_d VDD pmos_rvt L=2e-08 W=2.7e-08 nfin=1
M18 N_M5_g N_M3_d VDD VDD pmos_rvt L=2e-08 W=2.7e-08 nfin=1
M19 N_M7_d N_M0_s N_M5_g VDD pmos_rvt L=2e-08 W=2.7e-08 nfin=1
M20 N_M20_d N_M1_d N_M7_d VDD pmos_rvt L=2e-08 W=2.7e-08 nfin=1
M21 VDD N_M9_g N_M20_d VDD pmos_rvt L=2e-08 W=2.7e-08 nfin=1
M22 N_M9_g N_M7_d VDD VDD pmos_rvt L=2e-08 W=2.7e-08 nfin=1
M23 QN N_M7_d VDD VDD pmos_rvt L=2e-08 W=8.1e-08 nfin=3
.ENDS

.SUBCKT DFFHQNx2_ASAP7_75t_R CLK D QN VDD VSS
MM24 QN net32 VSS VSS nmos_rvt w=162.00n l=20n nfin=6
MM17 net32 clkn pd5 VSS nmos_rvt w=27.0n l=20n nfin=1
MM16 pd5 net37 VSS VSS nmos_rvt w=27.0n l=20n nfin=1
MM14 net37 net32 VSS VSS nmos_rvt w=27.0n l=20n nfin=1
MM12 net29 clkb net32 VSS nmos_rvt w=27.0n l=20n nfin=1
MM6 net29 net15 VSS VSS nmos_rvt w=27.0n l=20n nfin=1
MM9 net15 clkb pd3 VSS nmos_rvt w=27.0n l=20n nfin=1
MM8 pd3 net29 VSS VSS nmos_rvt w=27.0n l=20n nfin=1
MM23 clkb clkn VSS VSS nmos_rvt w=54.0n l=20n nfin=2
MM5 pd1 D VSS VSS nmos_rvt w=81.0n l=20n nfin=3
MM4 net15 clkn pd1 VSS nmos_rvt w=81.0n l=20n nfin=3
MM20 clkn CLK VSS VSS nmos_rvt w=54.0n l=20n nfin=2
MM25 QN net32 VDD VDD pmos_rvt w=162.00n l=20n nfin=6
MM19 pd4 net37 VDD VDD pmos_rvt w=27n l=20n nfin=1
MM18 net32 clkb pd4 VDD pmos_rvt w=27n l=20n nfin=1
MM15 net37 net32 VDD VDD pmos_rvt w=27n l=20n nfin=1
MM13 net29 clkn net32 VDD pmos_rvt w=27n l=20n nfin=1
MM7 net29 net15 VDD VDD pmos_rvt w=27n l=20n nfin=1
MM11 pd2 net29 VDD VDD pmos_rvt w=27n l=20n nfin=1
MM10 net15 clkn pd2 VDD pmos_rvt w=27n l=20n nfin=1
MM22 clkb clkn VDD VDD pmos_rvt w=54.0n l=20n nfin=2
MM1 net15 clkb pu1 VDD pmos_rvt w=81.0n l=20n nfin=3
MM3 pu1 D VDD VDD pmos_rvt w=81.0n l=20n nfin=3
MM21 clkn CLK VDD VDD pmos_rvt w=54.0n l=20n nfin=2
.ENDS

.SUBCKT DFFHQNx3_ASAP7_75t_R CLK D QN VDD VSS
MM24 QN SH VSS VSS nmos_rvt w=243.00n l=20n nfin=9
MM23 clkb clkn VSS VSS nmos_rvt w=54.0n l=20n nfin=2
MM20 clkn CLK VSS VSS nmos_rvt w=54.0n l=20n nfin=2
MM17 SH clkn pd5 VSS nmos_rvt w=27.0n l=20n nfin=1
MM16 pd5 SS VSS VSS nmos_rvt w=27.0n l=20n nfin=1
MM14 SS SH VSS VSS nmos_rvt w=27.0n l=20n nfin=1
MM12 MS clkb SH VSS nmos_rvt w=27.0n l=20n nfin=1
MM9 MH clkb pd3 VSS nmos_rvt w=27.0n l=20n nfin=1
MM8 pd3 MS VSS VSS nmos_rvt w=27.0n l=20n nfin=1
MM6 MS MH VSS VSS nmos_rvt w=27.0n l=20n nfin=1
MM5 pd1 D VSS VSS nmos_rvt w=81.0n l=20n nfin=3
MM4 MH clkn pd1 VSS nmos_rvt w=81.0n l=20n nfin=3
MM25 QN SH VDD VDD pmos_rvt w=243.00n l=20n nfin=9
MM22 clkb clkn VDD VDD pmos_rvt w=54.0n l=20n nfin=2
MM21 clkn CLK VDD VDD pmos_rvt w=54.0n l=20n nfin=2
MM19 pd4 SS VDD VDD pmos_rvt w=27n l=20n nfin=1
MM18 SH clkb pd4 VDD pmos_rvt w=27n l=20n nfin=1
MM15 SS SH VDD VDD pmos_rvt w=27n l=20n nfin=1
MM13 MS clkn SH VDD pmos_rvt w=27.0n l=20n nfin=1
MM11 pd2 MS VDD VDD pmos_rvt w=27n l=20n nfin=1
MM10 MH clkn pd2 VDD pmos_rvt w=27.0n l=20n nfin=1
MM7 MS MH VDD VDD pmos_rvt w=27.0n l=20n nfin=1
MM1 MH clkb pu1 VDD pmos_rvt w=81.0n l=20n nfin=3
MM3 pu1 D VDD VDD pmos_rvt w=81.0n l=20n nfin=3
.ENDS

.SUBCKT DFFHQx4_ASAP7_75t_R CLK D Q VDD VSS
MM38 Q net049 VSS VSS nmos_rvt w=324.00n l=20n nfin=12
MM24 net049 SH VSS VSS nmos_rvt w=162.00n l=20n nfin=6
MM23 clkb clkn VSS VSS nmos_rvt w=54.0n l=20n nfin=2
MM20 clkn CLK VSS VSS nmos_rvt w=54.0n l=20n nfin=2
MM17 SH clkn pd5 VSS nmos_rvt w=27.0n l=20n nfin=1
MM16 pd5 SS VSS VSS nmos_rvt w=27.0n l=20n nfin=1
MM14 SS SH VSS VSS nmos_rvt w=27.0n l=20n nfin=1
MM12 MS clkb SH VSS nmos_rvt w=27.0n l=20n nfin=1
MM9 MH clkb pd3 VSS nmos_rvt w=27.0n l=20n nfin=1
MM8 pd3 MS VSS VSS nmos_rvt w=27.0n l=20n nfin=1
MM6 MS MH VSS VSS nmos_rvt w=27.0n l=20n nfin=1
MM5 pd1 D VSS VSS nmos_rvt w=81.0n l=20n nfin=3
MM4 MH clkn pd1 VSS nmos_rvt w=81.0n l=20n nfin=3
MM25 net049 SH VDD VDD pmos_rvt w=162.00n l=20n nfin=6
MM22 clkb clkn VDD VDD pmos_rvt w=54.0n l=20n nfin=2
MM21 clkn CLK VDD VDD pmos_rvt w=54.0n l=20n nfin=2
MM19 pd4 SS VDD VDD pmos_rvt w=27n l=20n nfin=1
MM18 SH clkb pd4 VDD pmos_rvt w=27n l=20n nfin=1
MM15 SS SH VDD VDD pmos_rvt w=27n l=20n nfin=1
MM13 MS clkn SH VDD pmos_rvt w=27.0n l=20n nfin=1
MM11 pd2 MS VDD VDD pmos_rvt w=27n l=20n nfin=1
MM10 MH clkn pd2 VDD pmos_rvt w=27n l=20n nfin=1
MM7 MS MH VDD VDD pmos_rvt w=27n l=20n nfin=1
MM1 MH clkb pu1 VDD pmos_rvt w=81.0n l=20n nfin=3
MM37 Q net049 VDD VDD pmos_rvt w=324.00n l=20n nfin=12
MM3 pu1 D VDD VDD pmos_rvt w=81.0n l=20n nfin=3
.ENDS

.SUBCKT DFFLQNx1_ASAP7_75t_R CLK D QN VDD VSS
MM24 QN SH VSS VSS nmos_rvt w=81.0n l=20n nfin=3
MM23 clkb clkn VSS VSS nmos_rvt w=54.0n l=20n nfin=2
MM20 clkn CLK VSS VSS nmos_rvt w=54.0n l=20n nfin=2
MM17 SH clkb net0107 VSS nmos_rvt w=27.0n l=20n nfin=1
MM16 net0107 SS VSS VSS nmos_rvt w=27.0n l=20n nfin=1
MM14 SS SH VSS VSS nmos_rvt w=27.0n l=20n nfin=1
MM12 net029 clkn SH VSS nmos_rvt w=27.0n l=20n nfin=1
MM9 MH clkn net0109 VSS nmos_rvt w=27.0n l=20n nfin=1
MM8 net0109 net029 VSS VSS nmos_rvt w=27.0n l=20n nfin=1
MM6 net029 MH VSS VSS nmos_rvt w=27.0n l=20n nfin=1
MM5 net020 D VSS VSS nmos_rvt w=81.0n l=20n nfin=3
MM4 MH clkb net020 VSS nmos_rvt w=81.0n l=20n nfin=3
MM25 QN SH VDD VDD pmos_rvt w=81.0n l=20n nfin=3
MM13 net029 clkb SH VDD pmos_rvt w=27n l=20n nfin=1
MM22 clkb clkn VDD VDD pmos_rvt w=54.0n l=20n nfin=2
MM21 clkn CLK VDD VDD pmos_rvt w=54.0n l=20n nfin=2
MM19 net0108 SS VDD VDD pmos_rvt w=27.0n l=20n nfin=1
MM18 SH clkn net0108 VDD pmos_rvt w=27.0n l=20n nfin=1
MM15 SS SH VDD VDD pmos_rvt w=27.0n l=20n nfin=1
MM11 net0110 net029 VDD VDD pmos_rvt w=27.0n l=20n nfin=1
MM10 MH clkb net0110 VDD pmos_rvt w=27.0n l=20n nfin=1
MM7 net029 MH VDD VDD pmos_rvt w=27.0n l=20n nfin=1
MM1 MH clkn net06 VDD pmos_rvt w=81.0n l=20n nfin=3
MM3 net06 D VDD VDD pmos_rvt w=81.0n l=20n nfin=3
.ENDS

.SUBCKT DFFLQNx2_ASAP7_75t_R CLK D QN VDD VSS
MM24 QN SH VSS VSS nmos_rvt w=162.00n l=20n nfin=6
MM23 clkb clkn VSS VSS nmos_rvt w=54.0n l=20n nfin=2
MM20 clkn CLK VSS VSS nmos_rvt w=54.0n l=20n nfin=2
MM17 SH clkb pd5 VSS nmos_rvt w=27.0n l=20n nfin=1
MM16 pd5 SS VSS VSS nmos_rvt w=27.0n l=20n nfin=1
MM14 SS SH VSS VSS nmos_rvt w=27.0n l=20n nfin=1
MM12 MS clkn SH VSS nmos_rvt w=27.0n l=20n nfin=1
MM9 MH clkn pd3 VSS nmos_rvt w=27.0n l=20n nfin=1
MM8 pd3 MS VSS VSS nmos_rvt w=27.0n l=20n nfin=1
MM6 MS MH VSS VSS nmos_rvt w=27.0n l=20n nfin=1
MM5 pd1 D VSS VSS nmos_rvt w=81.0n l=20n nfin=3
MM4 MH clkb pd1 VSS nmos_rvt w=81.0n l=20n nfin=3
MM25 QN SH VDD VDD pmos_rvt w=162.00n l=20n nfin=6
MM22 clkb clkn VDD VDD pmos_rvt w=54.0n l=20n nfin=2
MM21 clkn CLK VDD VDD pmos_rvt w=54.0n l=20n nfin=2
MM19 pd4 SS VDD VDD pmos_rvt w=27n l=20n nfin=1
MM18 SH clkn pd4 VDD pmos_rvt w=27n l=20n nfin=1
MM15 SS SH VDD VDD pmos_rvt w=27n l=20n nfin=1
MM13 MS clkb SH VDD pmos_rvt w=27n l=20n nfin=1
MM11 pd2 MS VDD VDD pmos_rvt w=27n l=20n nfin=1
MM10 MH clkb pd2 VDD pmos_rvt w=27n l=20n nfin=1
MM7 MS MH VDD VDD pmos_rvt w=27n l=20n nfin=1
MM1 MH clkn pu1 VDD pmos_rvt w=81.0n l=20n nfin=3
MM3 pu1 D VDD VDD pmos_rvt w=81.0n l=20n nfin=3
.ENDS

.SUBCKT DFFLQNx3_ASAP7_75t_R CLK D QN VDD VSS
MM27 clkb clkn VSS VSS nmos_rvt w=54.0n l=20n nfin=2
MM0 clkn CLK VSS VSS nmos_rvt w=54.0n l=20n nfin=2
MM24 QN SH VSS VSS nmos_rvt w=243.00n l=20n nfin=9
MM17 SH clkb pd5 VSS nmos_rvt w=27.0n l=20n nfin=1
MM16 pd5 SS VSS VSS nmos_rvt w=27.0n l=20n nfin=1
MM14 SS SH VSS VSS nmos_rvt w=27.0n l=20n nfin=1
MM12 MS clkn SH VSS nmos_rvt w=27.0n l=20n nfin=1
MM6 MS MH VSS VSS nmos_rvt w=27.0n l=20n nfin=1
MM9 MH clkn pd3 VSS nmos_rvt w=27.0n l=20n nfin=1
MM8 pd3 MS VSS VSS nmos_rvt w=27.0n l=20n nfin=1
MM5 pd1 D VSS VSS nmos_rvt w=81.0n l=20n nfin=3
MM4 MH clkb pd1 VSS nmos_rvt w=81.0n l=20n nfin=3
MM26 clkb clkn VDD VDD pmos_rvt w=54.0n l=20n nfin=2
MM2 clkn CLK VDD VDD pmos_rvt w=54.0n l=20n nfin=2
MM25 QN SH VDD VDD pmos_rvt w=243.00n l=20n nfin=9
MM19 pd4 SS VDD VDD pmos_rvt w=27n l=20n nfin=1
MM18 SH clkn pd4 VDD pmos_rvt w=27n l=20n nfin=1
MM15 SS SH VDD VDD pmos_rvt w=27n l=20n nfin=1
MM13 MS clkb SH VDD pmos_rvt w=27n l=20n nfin=1
MM7 MS MH VDD VDD pmos_rvt w=27n l=20n nfin=1
MM11 pd2 MS VDD VDD pmos_rvt w=27n l=20n nfin=1
MM10 MH clkb pd2 VDD pmos_rvt w=27n l=20n nfin=1
MM1 MH clkn pu1 VDD pmos_rvt w=81.0n l=20n nfin=3
MM3 pu1 D VDD VDD pmos_rvt w=81.0n l=20n nfin=3
.ENDS

.SUBCKT DFFLQx4_ASAP7_75t_R CLK D Q VDD VSS
MM0 Q QN VSS VSS nmos_rvt w=324.00n l=20n nfin=12
MM24 QN SH VSS VSS nmos_rvt w=162.00n l=20n nfin=6
MM17 SH clkb pd5 VSS nmos_rvt w=27.0n l=20n nfin=1
MM16 pd5 SS VSS VSS nmos_rvt w=27.0n l=20n nfin=1
MM14 SS SH VSS VSS nmos_rvt w=27.0n l=20n nfin=1
MM12 MS clkn SH VSS nmos_rvt w=27.0n l=20n nfin=1
MM6 MS MH VSS VSS nmos_rvt w=27.0n l=20n nfin=1
MM9 MH clkn pd3 VSS nmos_rvt w=27.0n l=20n nfin=1
MM8 pd3 MS VSS VSS nmos_rvt w=27.0n l=20n nfin=1
MM23 clkb clkn VSS VSS nmos_rvt w=54.0n l=20n nfin=2
MM5 pd1 D VSS VSS nmos_rvt w=81.0n l=20n nfin=3
MM4 MH clkb pd1 VSS nmos_rvt w=81.0n l=20n nfin=3
MM20 clkn CLK VSS VSS nmos_rvt w=54.0n l=20n nfin=2
MM2 Q QN VDD VDD pmos_rvt w=324.00n l=20n nfin=12
MM25 QN SH VDD VDD pmos_rvt w=162.00n l=20n nfin=6
MM19 pd4 SS VDD VDD pmos_rvt w=27n l=20n nfin=1
MM18 SH clkn pd4 VDD pmos_rvt w=27n l=20n nfin=1
MM15 SS SH VDD VDD pmos_rvt w=27n l=20n nfin=1
MM13 MS clkb SH VDD pmos_rvt w=27n l=20n nfin=1
MM7 MS MH VDD VDD pmos_rvt w=27n l=20n nfin=1
MM11 pd2 MS VDD VDD pmos_rvt w=27n l=20n nfin=1
MM10 MH clkb pd2 VDD pmos_rvt w=27n l=20n nfin=1
MM22 clkb clkn VDD VDD pmos_rvt w=54.0n l=20n nfin=2
MM1 MH clkn pu1 VDD pmos_rvt w=81.0n l=20n nfin=3
MM3 pu1 D VDD VDD pmos_rvt w=81.0n l=20n nfin=3
MM21 clkn CLK VDD VDD pmos_rvt w=54.0n l=20n nfin=2
.ENDS

.SUBCKT DHLx1_ASAP7_75t_R CLK D Q VDD VSS
MM5 pd1 D VSS VSS nmos_rvt w=81.0n l=20n nfin=3
MM4 MH clkb pd1 VSS nmos_rvt w=81.0n l=20n nfin=3
MM2 clkb clkn VSS VSS nmos_rvt w=54.0n l=20n nfin=2
MM0 clkn CLK VSS VSS nmos_rvt w=54.0n l=20n nfin=2
MM24 Q MH VSS VSS nmos_rvt w=81.0n l=20n nfin=3
MM6 net088 MH VSS VSS nmos_rvt w=27.0n l=20n nfin=1
MM9 MH clkn pd3 VSS nmos_rvt w=27.0n l=20n nfin=1
MM8 pd3 net088 VSS VSS nmos_rvt w=27.0n l=20n nfin=1
MM1 MH clkn pu1 VDD pmos_rvt w=81.0n l=20n nfin=3
MM3 pu1 D VDD VDD pmos_rvt w=81.0n l=20n nfin=3
MM13 clkb clkn VDD VDD pmos_rvt w=54.0n l=20n nfin=2
MM25 Q MH VDD VDD pmos_rvt w=81.0n l=20n nfin=3
MM12 clkn CLK VDD VDD pmos_rvt w=54.0n l=20n nfin=2
MM7 net088 MH VDD VDD pmos_rvt w=27.0n l=20n nfin=1
MM11 pd2 net088 VDD VDD pmos_rvt w=27.0n l=20n nfin=1
MM10 MH clkb pd2 VDD pmos_rvt w=27n l=20n nfin=1
.ENDS

.SUBCKT DHLx2_ASAP7_75t_R CLK D Q VDD VSS
MM5 pd1 D VSS VSS nmos_rvt w=81.0n l=20n nfin=3
MM4 MH clkb pd1 VSS nmos_rvt w=81.0n l=20n nfin=3
MM2 clkb clkn VSS VSS nmos_rvt w=54.0n l=20n nfin=2
MM24 Q MH VSS VSS nmos_rvt w=162.00n l=20n nfin=6
MM0 clkn CLK VSS VSS nmos_rvt w=54.0n l=20n nfin=2
MM6 net088 MH VSS VSS nmos_rvt w=27.0n l=20n nfin=1
MM9 MH clkn pd3 VSS nmos_rvt w=27.0n l=20n nfin=1
MM8 pd3 net088 VSS VSS nmos_rvt w=27.0n l=20n nfin=1
MM11 pd2 net088 VDD VDD pmos_rvt w=27.0n l=20n nfin=1
MM10 MH clkb pd2 VDD pmos_rvt w=27n l=20n nfin=1
MM1 MH clkn pu1 VDD pmos_rvt w=81.0n l=20n nfin=3
MM3 pu1 D VDD VDD pmos_rvt w=81.0n l=20n nfin=3
MM13 clkb clkn VDD VDD pmos_rvt w=54.0n l=20n nfin=2
MM12 clkn CLK VDD VDD pmos_rvt w=54.0n l=20n nfin=2
MM25 Q MH VDD VDD pmos_rvt w=162.00n l=20n nfin=6
MM7 net088 MH VDD VDD pmos_rvt w=27.0n l=20n nfin=1
.ENDS

.SUBCKT DHLx3_ASAP7_75t_R CLK D Q VDD VSS
MM24 Q MH VSS VSS nmos_rvt w=243.00n l=20n nfin=9
MM6 net29 MH VSS VSS nmos_rvt w=27.0n l=20n nfin=1
MM9 MH clkn pd3 VSS nmos_rvt w=27.0n l=20n nfin=1
MM8 pd3 net29 VSS VSS nmos_rvt w=27.0n l=20n nfin=1
MM5 pd1 D VSS VSS nmos_rvt w=81.0n l=20n nfin=3
MM4 MH clkb pd1 VSS nmos_rvt w=81.0n l=20n nfin=3
MM2 clkb clkn VSS VSS nmos_rvt w=54.0n l=20n nfin=2
MM0 clkn CLK VSS VSS nmos_rvt w=54.0n l=20n nfin=2
MM25 Q MH VDD VDD pmos_rvt w=243.00n l=20n nfin=9
MM7 net29 MH VDD VDD pmos_rvt w=27.0n l=20n nfin=1
MM11 pd2 net29 VDD VDD pmos_rvt w=27.0n l=20n nfin=1
MM10 MH clkb pd2 VDD pmos_rvt w=27n l=20n nfin=1
MM1 MH clkn pu1 VDD pmos_rvt w=81.0n l=20n nfin=3
MM3 pu1 D VDD VDD pmos_rvt w=81.0n l=20n nfin=3
MM13 clkb clkn VDD VDD pmos_rvt w=54.0n l=20n nfin=2
MM12 clkn CLK VDD VDD pmos_rvt w=54.0n l=20n nfin=2
.ENDS

.SUBCKT DLLx1_ASAP7_75t_R CLK D Q VDD VSS
MM23 clkb clkn VSS VSS nmos_rvt w=54.0n l=20n nfin=2
MM5 pd1 D VSS VSS nmos_rvt w=81.0n l=20n nfin=3
MM4 MH clkn pd1 VSS nmos_rvt w=81.0n l=20n nfin=3
MM20 clkn CLK VSS VSS nmos_rvt w=54.0n l=20n nfin=2
MM24 Q MH VSS VSS nmos_rvt w=81.0n l=20n nfin=3
MM6 net085 MH VSS VSS nmos_rvt w=27.0n l=20n nfin=1
MM9 MH clkb pd3 VSS nmos_rvt w=27.0n l=20n nfin=1
MM8 pd3 net085 VSS VSS nmos_rvt w=27.0n l=20n nfin=1
MM22 clkb clkn VDD VDD pmos_rvt w=54.0n l=20n nfin=2
MM1 MH clkb pu1 VDD pmos_rvt w=81.0n l=20n nfin=3
MM3 pu1 D VDD VDD pmos_rvt w=81.0n l=20n nfin=3
MM25 Q MH VDD VDD pmos_rvt w=81.0n l=20n nfin=3
MM21 clkn CLK VDD VDD pmos_rvt w=54.0n l=20n nfin=2
MM7 net085 MH VDD VDD pmos_rvt w=27n l=20n nfin=1
MM11 pd2 net085 VDD VDD pmos_rvt w=27n l=20n nfin=1
MM10 MH clkn pd2 VDD pmos_rvt w=27n l=20n nfin=1
.ENDS

.SUBCKT DLLx2_ASAP7_75t_R CLK D Q VDD VSS
MM23 clkb clkn VSS VSS nmos_rvt w=54.0n l=20n nfin=2
MM5 pd1 D VSS VSS nmos_rvt w=81.0n l=20n nfin=3
MM4 MH clkn pd1 VSS nmos_rvt w=81.0n l=20n nfin=3
MM24 Q MH VSS VSS nmos_rvt w=162.00n l=20n nfin=6
MM20 clkn CLK VSS VSS nmos_rvt w=54.0n l=20n nfin=2
MM6 net085 MH VSS VSS nmos_rvt w=27.0n l=20n nfin=1
MM9 MH clkb pd3 VSS nmos_rvt w=27.0n l=20n nfin=1
MM8 pd3 net085 VSS VSS nmos_rvt w=27.0n l=20n nfin=1
MM11 pd2 net085 VDD VDD pmos_rvt w=27n l=20n nfin=1
MM10 MH clkn pd2 VDD pmos_rvt w=27n l=20n nfin=1
MM22 clkb clkn VDD VDD pmos_rvt w=54.0n l=20n nfin=2
MM1 MH clkb pu1 VDD pmos_rvt w=81.0n l=20n nfin=3
MM3 pu1 D VDD VDD pmos_rvt w=81.0n l=20n nfin=3
MM21 clkn CLK VDD VDD pmos_rvt w=54.0n l=20n nfin=2
MM25 Q MH VDD VDD pmos_rvt w=162.00n l=20n nfin=6
MM7 net085 MH VDD VDD pmos_rvt w=27n l=20n nfin=1
.ENDS

.SUBCKT DLLx3_ASAP7_75t_R CLK D Q VDD VSS
MM24 Q MH VSS VSS nmos_rvt w=243.00n l=20n nfin=9
MM6 net30 MH VSS VSS nmos_rvt w=27.0n l=20n nfin=1
MM9 MH clkb pd3 VSS nmos_rvt w=27.0n l=20n nfin=1
MM8 pd3 net30 VSS VSS nmos_rvt w=27.0n l=20n nfin=1
MM23 clkb clkn VSS VSS nmos_rvt w=54.0n l=20n nfin=2
MM5 pd1 D VSS VSS nmos_rvt w=81.0n l=20n nfin=3
MM4 MH clkn pd1 VSS nmos_rvt w=81.0n l=20n nfin=3
MM20 clkn CLK VSS VSS nmos_rvt w=54.0n l=20n nfin=2
MM25 Q MH VDD VDD pmos_rvt w=243.00n l=20n nfin=9
MM7 net30 MH VDD VDD pmos_rvt w=27n l=20n nfin=1
MM11 pd2 net30 VDD VDD pmos_rvt w=27n l=20n nfin=1
MM10 MH clkn pd2 VDD pmos_rvt w=27n l=20n nfin=1
MM22 clkb clkn VDD VDD pmos_rvt w=54.0n l=20n nfin=2
MM1 MH clkb pu1 VDD pmos_rvt w=81.0n l=20n nfin=3
MM3 pu1 D VDD VDD pmos_rvt w=81.0n l=20n nfin=3
MM21 clkn CLK VDD VDD pmos_rvt w=54.0n l=20n nfin=2
.ENDS

.SUBCKT FAx1_ASAP7_75t_R A B CI CON SN VDD VSS
M0 VSS A N_M0_s VSS nmos_rvt L=2e-08 W=8.1e-08 nfin=3
M1 N_M1_d A VSS VSS nmos_rvt L=2e-08 W=8.1e-08 nfin=3
M2 CON B N_M1_d VSS nmos_rvt L=2e-08 W=8.1e-08 nfin=3
M3 N_M0_s CI CON VSS nmos_rvt L=2e-08 W=8.1e-08 nfin=3
M4 VSS B N_M0_s VSS nmos_rvt L=2e-08 W=8.1e-08 nfin=3
M5 N_M5_d B VSS VSS nmos_rvt L=2e-08 W=8.1e-08 nfin=3
M6 N_M6_d A N_M5_d VSS nmos_rvt L=2e-08 W=8.1e-08 nfin=3
M7 SN CI N_M6_d VSS nmos_rvt L=2e-08 W=8.1e-08 nfin=3
M8 N_M8_d CON SN VSS nmos_rvt L=2e-08 W=8.1e-08 nfin=3
M9 VSS CI N_M8_d VSS nmos_rvt L=2e-08 W=8.1e-08 nfin=3
M10 N_M8_d A VSS VSS nmos_rvt L=2e-08 W=8.1e-08 nfin=3
M11 VSS B N_M8_d VSS nmos_rvt L=2e-08 W=8.1e-08 nfin=3
M12 VDD A N_M12_s VDD pmos_rvt L=2e-08 W=8.1e-08 nfin=3
M13 N_M13_d A VDD VDD pmos_rvt L=2e-08 W=8.1e-08 nfin=3
M14 CON B N_M13_d VDD pmos_rvt L=2e-08 W=8.1e-08 nfin=3
M15 N_M12_s CI CON VDD pmos_rvt L=2e-08 W=8.1e-08 nfin=3
M16 VDD B N_M12_s VDD pmos_rvt L=2e-08 W=8.1e-08 nfin=3
M17 N_M17_d B VDD VDD pmos_rvt L=2e-08 W=8.1e-08 nfin=3
M18 N_M18_d A N_M17_d VDD pmos_rvt L=2e-08 W=8.1e-08 nfin=3
M19 SN CI N_M18_d VDD pmos_rvt L=2e-08 W=8.1e-08 nfin=3
M20 N_M20_d CON SN VDD pmos_rvt L=2e-08 W=8.1e-08 nfin=3
M21 VDD CI N_M20_d VDD pmos_rvt L=2e-08 W=8.1e-08 nfin=3
M22 N_M20_d A VDD VDD pmos_rvt L=2e-08 W=8.1e-08 nfin=3
M23 VDD B N_M20_d VDD pmos_rvt L=2e-08 W=8.1e-08 nfin=3
.ENDS

.SUBCKT HAxp5_ASAP7_75t_R A B CON SN VDD VSS
M0 N_M0_d A VSS VSS nmos_rvt L=2e-08 W=8.1e-08 nfin=3
M1 CON B N_M0_d VSS nmos_rvt L=2e-08 W=8.1e-08 nfin=3
M2 VSS B noxref_6 VSS nmos_rvt L=2e-08 W=8.1e-08 nfin=3
M3 noxref_6 A VSS VSS nmos_rvt L=2e-08 W=8.1e-08 nfin=3
M4 SN CON noxref_6 VSS nmos_rvt L=2e-08 W=8.1e-08 nfin=3
M5 CON A VDD VDD pmos_rvt L=2e-08 W=5.4e-08 nfin=2
M6 VDD B CON VDD pmos_rvt L=2e-08 W=5.4e-08 nfin=2
M7 noxref_9 B SN VDD pmos_rvt L=2e-08 W=8.1e-08 nfin=3
M8 VDD A noxref_9 VDD pmos_rvt L=2e-08 W=8.1e-08 nfin=3
M9 SN CON VDD VDD pmos_rvt L=2e-08 W=8.1e-08 nfin=3
.ENDS

.SUBCKT HB1xp67_ASAP7_75t_R A VDD VSS Y
MM23 Y net7 VSS VSS nmos_rvt w=54.0n l=20n nfin=2
MM20 net7 A VSS VSS nmos_rvt w=27.0n l=20n nfin=1
MM22 Y net7 VDD VDD pmos_rvt w=54.0n l=20n nfin=2
MM21 net7 A VDD VDD pmos_rvt w=27.0n l=20n nfin=1
.ENDS

.SUBCKT HB2xp67_ASAP7_75t_R A VDD VSS Y
MM5 Y Abar VSS VSS nmos_rvt w=54.0n l=20n nfin=2
MM1 net17 A VSS VSS nmos_rvt w=27.0n l=20n nfin=1
MM0 Abar A net17 VSS nmos_rvt w=27.0n l=20n nfin=1
MM4 Y Abar VDD VDD pmos_rvt w=54.0n l=20n nfin=2
MM3 net16 A VDD VDD pmos_rvt w=27.0n l=20n nfin=1
MM2 Abar A net16 VDD pmos_rvt w=27.0n l=20n nfin=1
.ENDS

.SUBCKT HB3xp67_ASAP7_75t_R A VDD VSS Y
MM3 Y net11 VDD VDD pmos_rvt w=54.0n l=20n nfin=2
MM2 net11 A net18 VDD pmos_rvt w=27n l=20n nfin=1
MM1 net18 A net19 VDD pmos_rvt w=27n l=20n nfin=1
MM0 net19 A VDD VDD pmos_rvt w=27n l=20n nfin=1
MM7 net16 A VSS VSS nmos_rvt w=27n l=20n nfin=1
MM4 Y net11 VSS VSS nmos_rvt w=54.0n l=20n nfin=2
MM5 net11 A net17 VSS nmos_rvt w=27n l=20n nfin=1
MM6 net17 A net16 VSS nmos_rvt w=27n l=20n nfin=1
.ENDS

.SUBCKT HB4xp67_ASAP7_75t_R A VDD VSS Y
MM9 net16 A net17 VSS nmos_rvt w=27.0n l=20n nfin=1
MM8 net17 A VSS VSS nmos_rvt w=27.0n l=20n nfin=1
MM3 net5 A net18 VSS nmos_rvt w=27.0n l=20n nfin=1
MM0 Y net5 VSS VSS nmos_rvt w=54.0n l=20n nfin=2
MM7 net18 A net16 VSS nmos_rvt w=27.0n l=20n nfin=1
MM6 net20 A net21 VDD pmos_rvt w=27.0n l=20n nfin=1
MM5 net21 A VDD VDD pmos_rvt w=27.0n l=20n nfin=1
MM2 net5 A net19 VDD pmos_rvt w=27.0n l=20n nfin=1
MM4 net19 A net20 VDD pmos_rvt w=27.0n l=20n nfin=1
MM1 Y net5 VDD VDD pmos_rvt w=54.0n l=20n nfin=2
.ENDS

.SUBCKT ICGx1_ASAP7_75t_R CLK ENA GCLK SE VDD VSS
MM18 nos1 SE VDD VDD pmos_rvt w=54.0n l=20n nfin=2
MM16 gclkn CLK VDD VDD pmos_rvt w=108.00n l=20n nfin=4
MM7 MS MH VDD VDD pmos_rvt w=27n l=20n nfin=1
MM11 pd2 MS VDD VDD pmos_rvt w=27n l=20n nfin=1
MM10 MH clkn pd2 VDD pmos_rvt w=27n l=20n nfin=1
MM1 MH CLK pu1 VDD pmos_rvt w=81.0n l=20n nfin=3
MM3 pu1 net0121 VDD VDD pmos_rvt w=81.0n l=20n nfin=3
MM21 clkn CLK VDD VDD pmos_rvt w=81.0n l=20n nfin=3
MM25 GCLK gclkn VDD VDD pmos_rvt w=81.0n l=20n nfin=3
MM26 net0121 ENA nos1 VDD pmos_rvt w=54.0n l=20n nfin=2
MM0 gclkn MH VDD VDD pmos_rvt w=108.00n l=20n nfin=4
MM2 gclkn CLK net0140 VSS nmos_rvt w=81.0n l=20n nfin=3
MM12 net0141 MH VSS VSS nmos_rvt w=81.0n l=20n nfin=3
MM14 net0140 MH VSS VSS nmos_rvt w=81.0n l=20n nfin=3
MM6 MS MH VSS VSS nmos_rvt w=27.0n l=20n nfin=1
MM13 gclkn CLK net0141 VSS nmos_rvt w=81.0n l=20n nfin=3
MM9 MH CLK pd3 VSS nmos_rvt w=27.0n l=20n nfin=1
MM8 pd3 MS VSS VSS nmos_rvt w=27.0n l=20n nfin=1
MM27 net0121 SE VSS VSS nmos_rvt w=54.0n l=20n nfin=2
MM19 net0121 ENA VSS VSS nmos_rvt w=54.0n l=20n nfin=2
MM24 GCLK gclkn VSS VSS nmos_rvt w=81.0n l=20n nfin=3
MM5 pd1 net0121 VSS VSS nmos_rvt w=81.0n l=20n nfin=3
MM4 MH clkn pd1 VSS nmos_rvt w=81.0n l=20n nfin=3
MM20 clkn CLK VSS VSS nmos_rvt w=81.0n l=20n nfin=3
.ENDS

.SUBCKT ICGx2_ASAP7_75t_R CLK ENA GCLK SE VDD VSS
MM18 nos1 SE VDD VDD pmos_rvt w=54.0n l=20n nfin=2
MM16 gclkn CLK VDD VDD pmos_rvt w=108.00n l=20n nfin=4
MM7 MS MH VDD VDD pmos_rvt w=27n l=20n nfin=1
MM11 pd2 MS VDD VDD pmos_rvt w=27n l=20n nfin=1
MM10 MH clkn pd2 VDD pmos_rvt w=27n l=20n nfin=1
MM25 GCLK gclkn VDD VDD pmos_rvt w=162.00n l=20n nfin=6
MM1 MH CLK pu1 VDD pmos_rvt w=81.0n l=20n nfin=3
MM3 pu1 net0121 VDD VDD pmos_rvt w=81.0n l=20n nfin=3
MM21 clkn CLK VDD VDD pmos_rvt w=81.0n l=20n nfin=3
MM26 net0121 ENA nos1 VDD pmos_rvt w=54.0n l=20n nfin=2
MM0 gclkn MH VDD VDD pmos_rvt w=108.00n l=20n nfin=4
MM27 net0121 SE VSS VSS nmos_rvt w=54.0n l=20n nfin=2
MM13 gclkn CLK net0141 VSS nmos_rvt w=81.0n l=20n nfin=3
MM6 MS MH VSS VSS nmos_rvt w=27.0n l=20n nfin=1
MM12 net0141 MH VSS VSS nmos_rvt w=81.0n l=20n nfin=3
MM14 net0140 MH VSS VSS nmos_rvt w=81.0n l=20n nfin=3
MM2 gclkn CLK net0140 VSS nmos_rvt w=81.0n l=20n nfin=3
MM19 net0121 ENA VSS VSS nmos_rvt w=54.0n l=20n nfin=2
MM9 MH CLK pd3 VSS nmos_rvt w=27.0n l=20n nfin=1
MM8 pd3 MS VSS VSS nmos_rvt w=27.0n l=20n nfin=1
MM5 pd1 net0121 VSS VSS nmos_rvt w=81.0n l=20n nfin=3
MM4 MH clkn pd1 VSS nmos_rvt w=81.0n l=20n nfin=3
MM20 clkn CLK VSS VSS nmos_rvt w=81.0n l=20n nfin=3
MM24 GCLK gclkn VSS VSS nmos_rvt w=162.00n l=20n nfin=6
.ENDS

.SUBCKT ICGx2p67DC_ASAP7_75t_R CLK ENA GCLK SE VDD VSS
MM55 net0175 net0175 VDD VDD pmos_rvt w=162.00n l=20n nfin=6
MM54 net0175 net0212 VDD VDD pmos_rvt w=162.00n l=20n nfin=6
MM51 net0162 net0162 VDD VDD pmos_rvt w=162.00n l=20n nfin=6
MM47 gclkn2 CLK VDD VDD pmos_rvt w=108.00n l=20n nfin=4
MM46 gclkn2 MH VDD VDD pmos_rvt w=108.00n l=20n nfin=4
MM45 GCLK gclkn2 VDD VDD pmos_rvt w=54.0n l=20n nfin=2
MM18 nos1 SE VDD VDD pmos_rvt w=54.0n l=20n nfin=2
MM16 gclkn0 CLK VDD VDD pmos_rvt w=108.00n l=20n nfin=4
MM7 MS MH VDD VDD pmos_rvt w=27n l=20n nfin=1
MM11 pd2 MS VDD VDD pmos_rvt w=27n l=20n nfin=1
MM10 MH clkn pd2 VDD pmos_rvt w=27n l=20n nfin=1
MM25 GCLK gclkn0 VDD VDD pmos_rvt w=54.0n l=20n nfin=2
MM50 net0162 net0207 VDD VDD pmos_rvt w=162.00n l=20n nfin=6
MM1 MH CLK pu1 VDD pmos_rvt w=81.0n l=20n nfin=3
MM3 pu1 net0121 VDD VDD pmos_rvt w=81.0n l=20n nfin=3
MM21 clkn CLK VDD VDD pmos_rvt w=162.00n l=20n nfin=6
MM29 GCLK gclkn1 VDD VDD pmos_rvt w=54.0n l=20n nfin=2
MM30 gclkn1 MH VDD VDD pmos_rvt w=108.00n l=20n nfin=4
MM35 gclkn3 CLK VDD VDD pmos_rvt w=108.00n l=20n nfin=4
MM36 gclkn3 MH VDD VDD pmos_rvt w=108.00n l=20n nfin=4
MM37 GCLK gclkn3 VDD VDD pmos_rvt w=54.0n l=20n nfin=2
MM31 gclkn1 CLK VDD VDD pmos_rvt w=108.00n l=20n nfin=4
MM26 net0121 ENA nos1 VDD pmos_rvt w=54.0n l=20n nfin=2
MM0 gclkn0 MH VDD VDD pmos_rvt w=108.00n l=20n nfin=4
MM57 net0212 net0175 VSS VSS nmos_rvt w=162.00n l=20n nfin=6
MM56 net0212 net0212 VSS VSS nmos_rvt w=162.00n l=20n nfin=6
MM53 net0207 net0162 VSS VSS nmos_rvt w=162.00n l=20n nfin=6
MM52 net0207 net0207 VSS VSS nmos_rvt w=162.00n l=20n nfin=6
MM27 net0121 SE VSS VSS nmos_rvt w=54.0n l=20n nfin=2
MM13 gclkn0 CLK net0141 VSS nmos_rvt w=81.0n l=20n nfin=3
MM39 gclkn3 CLK net0244 VSS nmos_rvt w=81.0n l=20n nfin=3
MM6 MS MH VSS VSS nmos_rvt w=27.0n l=20n nfin=1
MM12 net0141 MH VSS VSS nmos_rvt w=81.0n l=20n nfin=3
MM40 net0243 MH VSS VSS nmos_rvt w=81.0n l=20n nfin=3
MM38 GCLK gclkn3 VSS VSS nmos_rvt w=54.0n l=20n nfin=2
MM14 net0140 MH VSS VSS nmos_rvt w=81.0n l=20n nfin=3
MM2 gclkn0 CLK net0140 VSS nmos_rvt w=81.0n l=20n nfin=3
MM19 net0121 ENA VSS VSS nmos_rvt w=54.0n l=20n nfin=2
MM9 MH CLK pd3 VSS nmos_rvt w=27.0n l=20n nfin=1
MM8 pd3 MS VSS VSS nmos_rvt w=27.0n l=20n nfin=1
MM15 net0247 MH VSS VSS nmos_rvt w=81.0n l=20n nfin=3
MM5 pd1 net0121 VSS VSS nmos_rvt w=81.0n l=20n nfin=3
MM4 MH clkn pd1 VSS nmos_rvt w=81.0n l=20n nfin=3
MM17 net0246 MH VSS VSS nmos_rvt w=81.0n l=20n nfin=3
MM22 gclkn1 CLK net0247 VSS nmos_rvt w=81.0n l=20n nfin=3
MM41 net0242 MH VSS VSS nmos_rvt w=81.0n l=20n nfin=3
MM42 gclkn2 CLK net0243 VSS nmos_rvt w=81.0n l=20n nfin=3
MM43 gclkn2 CLK net0242 VSS nmos_rvt w=81.0n l=20n nfin=3
MM32 net0245 MH VSS VSS nmos_rvt w=81.0n l=20n nfin=3
MM33 net0244 MH VSS VSS nmos_rvt w=81.0n l=20n nfin=3
MM20 clkn CLK VSS VSS nmos_rvt w=162.00n l=20n nfin=6
MM24 GCLK gclkn0 VSS VSS nmos_rvt w=54.0n l=20n nfin=2
MM23 gclkn1 CLK net0246 VSS nmos_rvt w=81.0n l=20n nfin=3
MM34 gclkn3 CLK net0245 VSS nmos_rvt w=81.0n l=20n nfin=3
MM44 GCLK gclkn2 VSS VSS nmos_rvt w=54.0n l=20n nfin=2
MM28 GCLK gclkn1 VSS VSS nmos_rvt w=54.0n l=20n nfin=2
.ENDS

.SUBCKT ICGx3_ASAP7_75t_R CLK ENA GCLK SE VDD VSS
MM0 gclkn MH VDD VDD pmos_rvt w=108.00n l=20n nfin=4
MM16 gclkn CLK VDD VDD pmos_rvt w=108.00n l=20n nfin=4
MM25 GCLK gclkn VDD VDD pmos_rvt w=243.00n l=20n nfin=9
MM7 MS MH VDD VDD pmos_rvt w=27n l=20n nfin=1
MM11 pd2 MS VDD VDD pmos_rvt w=27n l=20n nfin=1
MM10 MH clkn pd2 VDD pmos_rvt w=27n l=20n nfin=1
MM1 MH CLK pu1 VDD pmos_rvt w=81.0n l=20n nfin=3
MM3 pu1 net14 VDD VDD pmos_rvt w=81.0n l=20n nfin=3
MM21 clkn CLK VDD VDD pmos_rvt w=81.0n l=20n nfin=3
MM26 net14 ENA nos1 VDD pmos_rvt w=54.0n l=20n nfin=2
MM18 nos1 SE VDD VDD pmos_rvt w=54.0n l=20n nfin=2
MM24 GCLK gclkn VSS VSS nmos_rvt w=243.00n l=20n nfin=9
MM2 gclkn CLK net056 VSS nmos_rvt w=81.0n l=20n nfin=3
MM12 net059 MH VSS VSS nmos_rvt w=81.0n l=20n nfin=3
MM6 MS MH VSS VSS nmos_rvt w=27.0n l=20n nfin=1
MM9 MH CLK pd3 VSS nmos_rvt w=27.0n l=20n nfin=1
MM8 pd3 MS VSS VSS nmos_rvt w=27.0n l=20n nfin=1
MM5 pd1 net14 VSS VSS nmos_rvt w=81.0n l=20n nfin=3
MM4 MH clkn pd1 VSS nmos_rvt w=81.0n l=20n nfin=3
MM20 clkn CLK VSS VSS nmos_rvt w=81.0n l=20n nfin=3
MM14 net056 MH VSS VSS nmos_rvt w=81.0n l=20n nfin=3
MM13 gclkn CLK net059 VSS nmos_rvt w=81.0n l=20n nfin=3
MM27 net14 SE VSS VSS nmos_rvt w=54.0n l=20n nfin=2
MM19 net14 ENA VSS VSS nmos_rvt w=54.0n l=20n nfin=2
.ENDS

.SUBCKT ICGx4DC_ASAP7_75t_R CLK ENA GCLK SE VDD VSS
MM55 net0175 net0175 VDD VDD pmos_rvt w=162.00n l=20n nfin=6
MM54 net0175 net0212 VDD VDD pmos_rvt w=162.00n l=20n nfin=6
MM51 net0162 net0162 VDD VDD pmos_rvt w=162.00n l=20n nfin=6
MM47 gclkn2 CLK VDD VDD pmos_rvt w=108.00n l=20n nfin=4
MM46 gclkn2 MH VDD VDD pmos_rvt w=108.00n l=20n nfin=4
MM45 GCLK gclkn2 VDD VDD pmos_rvt w=54.0n l=20n nfin=2
MM18 nos1 SE VDD VDD pmos_rvt w=54.0n l=20n nfin=2
MM16 gclkn0 CLK VDD VDD pmos_rvt w=108.00n l=20n nfin=4
MM7 MS MH VDD VDD pmos_rvt w=27n l=20n nfin=1
MM11 pd2 MS VDD VDD pmos_rvt w=27n l=20n nfin=1
MM10 MH clkn pd2 VDD pmos_rvt w=27n l=20n nfin=1
MM25 GCLK gclkn0 VDD VDD pmos_rvt w=108.00n l=20n nfin=4
MM50 net0162 net0207 VDD VDD pmos_rvt w=162.00n l=20n nfin=6
MM1 MH CLK pu1 VDD pmos_rvt w=81.0n l=20n nfin=3
MM3 pu1 net0121 VDD VDD pmos_rvt w=81.0n l=20n nfin=3
MM21 clkn CLK VDD VDD pmos_rvt w=162.00n l=20n nfin=6
MM29 GCLK gclkn1 VDD VDD pmos_rvt w=108.00n l=20n nfin=4
MM30 gclkn1 MH VDD VDD pmos_rvt w=108.00n l=20n nfin=4
MM35 gclkn3 CLK VDD VDD pmos_rvt w=108.00n l=20n nfin=4
MM36 gclkn3 MH VDD VDD pmos_rvt w=108.00n l=20n nfin=4
MM37 GCLK gclkn3 VDD VDD pmos_rvt w=54.0n l=20n nfin=2
MM31 gclkn1 CLK VDD VDD pmos_rvt w=108.00n l=20n nfin=4
MM26 net0121 ENA nos1 VDD pmos_rvt w=54.0n l=20n nfin=2
MM0 gclkn0 MH VDD VDD pmos_rvt w=108.00n l=20n nfin=4
MM57 net0212 net0175 VSS VSS nmos_rvt w=162.00n l=20n nfin=6
MM56 net0212 net0212 VSS VSS nmos_rvt w=162.00n l=20n nfin=6
MM53 net0207 net0162 VSS VSS nmos_rvt w=162.00n l=20n nfin=6
MM52 net0207 net0207 VSS VSS nmos_rvt w=162.00n l=20n nfin=6
MM27 net0121 SE VSS VSS nmos_rvt w=54.0n l=20n nfin=2
MM13 gclkn0 CLK net0141 VSS nmos_rvt w=81.0n l=20n nfin=3
MM39 gclkn3 CLK net0244 VSS nmos_rvt w=81.0n l=20n nfin=3
MM6 MS MH VSS VSS nmos_rvt w=27.0n l=20n nfin=1
MM12 net0141 MH VSS VSS nmos_rvt w=81.0n l=20n nfin=3
MM40 net0243 MH VSS VSS nmos_rvt w=81.0n l=20n nfin=3
MM38 GCLK gclkn3 VSS VSS nmos_rvt w=54.0n l=20n nfin=2
MM14 net0140 MH VSS VSS nmos_rvt w=81.0n l=20n nfin=3
MM2 gclkn0 CLK net0140 VSS nmos_rvt w=81.0n l=20n nfin=3
MM19 net0121 ENA VSS VSS nmos_rvt w=54.0n l=20n nfin=2
MM9 MH CLK pd3 VSS nmos_rvt w=27.0n l=20n nfin=1
MM8 pd3 MS VSS VSS nmos_rvt w=27.0n l=20n nfin=1
MM15 net0247 MH VSS VSS nmos_rvt w=81.0n l=20n nfin=3
MM5 pd1 net0121 VSS VSS nmos_rvt w=81.0n l=20n nfin=3
MM4 MH clkn pd1 VSS nmos_rvt w=81.0n l=20n nfin=3
MM17 net0246 MH VSS VSS nmos_rvt w=81.0n l=20n nfin=3
MM22 gclkn1 CLK net0247 VSS nmos_rvt w=81.0n l=20n nfin=3
MM41 net0242 MH VSS VSS nmos_rvt w=81.0n l=20n nfin=3
MM42 gclkn2 CLK net0243 VSS nmos_rvt w=81.0n l=20n nfin=3
MM43 gclkn2 CLK net0242 VSS nmos_rvt w=81.0n l=20n nfin=3
MM32 net0245 MH VSS VSS nmos_rvt w=81.0n l=20n nfin=3
MM33 net0244 MH VSS VSS nmos_rvt w=81.0n l=20n nfin=3
MM20 clkn CLK VSS VSS nmos_rvt w=162.00n l=20n nfin=6
MM24 GCLK gclkn0 VSS VSS nmos_rvt w=108.00n l=20n nfin=4
MM23 gclkn1 CLK net0246 VSS nmos_rvt w=81.0n l=20n nfin=3
MM34 gclkn3 CLK net0245 VSS nmos_rvt w=81.0n l=20n nfin=3
MM44 GCLK gclkn2 VSS VSS nmos_rvt w=54.0n l=20n nfin=2
MM28 GCLK gclkn1 VSS VSS nmos_rvt w=108.00n l=20n nfin=4
.ENDS

.SUBCKT ICGx4_ASAP7_75t_R CLK ENA GCLK SE VDD VSS
MM0 gclkn MH VDD VDD pmos_rvt w=108.00n l=20n nfin=4
MM16 gclkn CLK VDD VDD pmos_rvt w=108.00n l=20n nfin=4
MM25 GCLK gclkn VDD VDD pmos_rvt w=324.00n l=20n nfin=12
MM7 MS MH VDD VDD pmos_rvt w=27n l=20n nfin=1
MM11 pd2 MS VDD VDD pmos_rvt w=27n l=20n nfin=1
MM10 MH clkn pd2 VDD pmos_rvt w=27n l=20n nfin=1
MM1 MH CLK pu1 VDD pmos_rvt w=81.0n l=20n nfin=3
MM3 pu1 net14 VDD VDD pmos_rvt w=81.0n l=20n nfin=3
MM21 clkn CLK VDD VDD pmos_rvt w=81.0n l=20n nfin=3
MM26 net14 ENA nos1 VDD pmos_rvt w=54.0n l=20n nfin=2
MM18 nos1 SE VDD VDD pmos_rvt w=54.0n l=20n nfin=2
MM24 GCLK gclkn VSS VSS nmos_rvt w=324.00n l=20n nfin=12
MM2 gclkn CLK net056 VSS nmos_rvt w=81.0n l=20n nfin=3
MM12 net059 MH VSS VSS nmos_rvt w=81.0n l=20n nfin=3
MM6 MS MH VSS VSS nmos_rvt w=27.0n l=20n nfin=1
MM9 MH CLK pd3 VSS nmos_rvt w=27.0n l=20n nfin=1
MM8 pd3 MS VSS VSS nmos_rvt w=27.0n l=20n nfin=1
MM5 pd1 net14 VSS VSS nmos_rvt w=81.0n l=20n nfin=3
MM4 MH clkn pd1 VSS nmos_rvt w=81.0n l=20n nfin=3
MM20 clkn CLK VSS VSS nmos_rvt w=81.0n l=20n nfin=3
MM14 net056 MH VSS VSS nmos_rvt w=81.0n l=20n nfin=3
MM13 gclkn CLK net059 VSS nmos_rvt w=81.0n l=20n nfin=3
MM27 net14 SE VSS VSS nmos_rvt w=54.0n l=20n nfin=2
MM19 net14 ENA VSS VSS nmos_rvt w=54.0n l=20n nfin=2
.ENDS

.SUBCKT ICGx5_ASAP7_75t_R CLK ENA GCLK SE VDD VSS
MM0 gclkn MH VDD VDD pmos_rvt w=108.00n l=20n nfin=4
MM16 gclkn CLK VDD VDD pmos_rvt w=108.00n l=20n nfin=4
MM25 GCLK gclkn VDD VDD pmos_rvt w=405.00n l=20n nfin=15
MM7 MS MH VDD VDD pmos_rvt w=27n l=20n nfin=1
MM11 pd2 MS VDD VDD pmos_rvt w=27n l=20n nfin=1
MM10 MH clkn pd2 VDD pmos_rvt w=27n l=20n nfin=1
MM1 MH CLK pu1 VDD pmos_rvt w=81.0n l=20n nfin=3
MM3 pu1 net14 VDD VDD pmos_rvt w=81.0n l=20n nfin=3
MM21 clkn CLK VDD VDD pmos_rvt w=81.0n l=20n nfin=3
MM26 net14 ENA nos1 VDD pmos_rvt w=54.0n l=20n nfin=2
MM18 nos1 SE VDD VDD pmos_rvt w=54.0n l=20n nfin=2
MM24 GCLK gclkn VSS VSS nmos_rvt w=405.00n l=20n nfin=15
MM2 gclkn CLK net056 VSS nmos_rvt w=81.0n l=20n nfin=3
MM12 net059 MH VSS VSS nmos_rvt w=81.0n l=20n nfin=3
MM6 MS MH VSS VSS nmos_rvt w=27.0n l=20n nfin=1
MM9 MH CLK pd3 VSS nmos_rvt w=27.0n l=20n nfin=1
MM8 pd3 MS VSS VSS nmos_rvt w=27.0n l=20n nfin=1
MM5 pd1 net14 VSS VSS nmos_rvt w=81.0n l=20n nfin=3
MM4 MH clkn pd1 VSS nmos_rvt w=81.0n l=20n nfin=3
MM20 clkn CLK VSS VSS nmos_rvt w=81.0n l=20n nfin=3
MM14 net056 MH VSS VSS nmos_rvt w=81.0n l=20n nfin=3
MM13 gclkn CLK net059 VSS nmos_rvt w=81.0n l=20n nfin=3
MM27 net14 SE VSS VSS nmos_rvt w=54.0n l=20n nfin=2
MM19 net14 ENA VSS VSS nmos_rvt w=54.0n l=20n nfin=2
.ENDS

.SUBCKT ICGx5p33DC_ASAP7_75t_R CLK ENA GCLK SE VDD VSS
MM55 net0175 net0175 VDD VDD pmos_rvt w=162.00n l=20n nfin=6
MM54 net0175 net0212 VDD VDD pmos_rvt w=162.00n l=20n nfin=6
MM51 net0162 net0162 VDD VDD pmos_rvt w=162.00n l=20n nfin=6
MM47 gclkn2 CLK VDD VDD pmos_rvt w=108.00n l=20n nfin=4
MM46 gclkn2 MH VDD VDD pmos_rvt w=108.00n l=20n nfin=4
MM45 GCLK gclkn2 VDD VDD pmos_rvt w=108.00n l=20n nfin=4
MM18 nos1 SE VDD VDD pmos_rvt w=54.0n l=20n nfin=2
MM16 gclkn0 CLK VDD VDD pmos_rvt w=108.00n l=20n nfin=4
MM7 MS MH VDD VDD pmos_rvt w=27n l=20n nfin=1
MM11 pd2 MS VDD VDD pmos_rvt w=27n l=20n nfin=1
MM10 MH clkn pd2 VDD pmos_rvt w=27n l=20n nfin=1
MM25 GCLK gclkn0 VDD VDD pmos_rvt w=108.00n l=20n nfin=4
MM50 net0162 net0207 VDD VDD pmos_rvt w=162.00n l=20n nfin=6
MM1 MH CLK pu1 VDD pmos_rvt w=81.0n l=20n nfin=3
MM3 pu1 net0121 VDD VDD pmos_rvt w=81.0n l=20n nfin=3
MM21 clkn CLK VDD VDD pmos_rvt w=162.00n l=20n nfin=6
MM29 GCLK gclkn1 VDD VDD pmos_rvt w=108.00n l=20n nfin=4
MM30 gclkn1 MH VDD VDD pmos_rvt w=108.00n l=20n nfin=4
MM35 gclkn3 CLK VDD VDD pmos_rvt w=108.00n l=20n nfin=4
MM36 gclkn3 MH VDD VDD pmos_rvt w=108.00n l=20n nfin=4
MM37 GCLK gclkn3 VDD VDD pmos_rvt w=108.00n l=20n nfin=4
MM31 gclkn1 CLK VDD VDD pmos_rvt w=108.00n l=20n nfin=4
MM26 net0121 ENA nos1 VDD pmos_rvt w=54.0n l=20n nfin=2
MM0 gclkn0 MH VDD VDD pmos_rvt w=108.00n l=20n nfin=4
MM57 net0212 net0175 VSS VSS nmos_rvt w=162.00n l=20n nfin=6
MM56 net0212 net0212 VSS VSS nmos_rvt w=162.00n l=20n nfin=6
MM53 net0207 net0162 VSS VSS nmos_rvt w=162.00n l=20n nfin=6
MM52 net0207 net0207 VSS VSS nmos_rvt w=162.00n l=20n nfin=6
MM27 net0121 SE VSS VSS nmos_rvt w=54.0n l=20n nfin=2
MM13 gclkn0 CLK net0141 VSS nmos_rvt w=81.0n l=20n nfin=3
MM39 gclkn3 CLK net0244 VSS nmos_rvt w=81.0n l=20n nfin=3
MM6 MS MH VSS VSS nmos_rvt w=27.0n l=20n nfin=1
MM12 net0141 MH VSS VSS nmos_rvt w=81.0n l=20n nfin=3
MM40 net0243 MH VSS VSS nmos_rvt w=81.0n l=20n nfin=3
MM38 GCLK gclkn3 VSS VSS nmos_rvt w=108.00n l=20n nfin=4
MM14 net0140 MH VSS VSS nmos_rvt w=81.0n l=20n nfin=3
MM2 gclkn0 CLK net0140 VSS nmos_rvt w=81.0n l=20n nfin=3
MM19 net0121 ENA VSS VSS nmos_rvt w=54.0n l=20n nfin=2
MM9 MH CLK pd3 VSS nmos_rvt w=27.0n l=20n nfin=1
MM8 pd3 MS VSS VSS nmos_rvt w=27.0n l=20n nfin=1
MM15 net0247 MH VSS VSS nmos_rvt w=81.0n l=20n nfin=3
MM5 pd1 net0121 VSS VSS nmos_rvt w=81.0n l=20n nfin=3
MM4 MH clkn pd1 VSS nmos_rvt w=81.0n l=20n nfin=3
MM17 net0246 MH VSS VSS nmos_rvt w=81.0n l=20n nfin=3
MM22 gclkn1 CLK net0247 VSS nmos_rvt w=81.0n l=20n nfin=3
MM41 net0242 MH VSS VSS nmos_rvt w=81.0n l=20n nfin=3
MM42 gclkn2 CLK net0243 VSS nmos_rvt w=81.0n l=20n nfin=3
MM43 gclkn2 CLK net0242 VSS nmos_rvt w=81.0n l=20n nfin=3
MM32 net0245 MH VSS VSS nmos_rvt w=81.0n l=20n nfin=3
MM33 net0244 MH VSS VSS nmos_rvt w=81.0n l=20n nfin=3
MM20 clkn CLK VSS VSS nmos_rvt w=162.00n l=20n nfin=6
MM24 GCLK gclkn0 VSS VSS nmos_rvt w=108.00n l=20n nfin=4
MM23 gclkn1 CLK net0246 VSS nmos_rvt w=81.0n l=20n nfin=3
MM34 gclkn3 CLK net0245 VSS nmos_rvt w=81.0n l=20n nfin=3
MM44 GCLK gclkn2 VSS VSS nmos_rvt w=108.00n l=20n nfin=4
MM28 GCLK gclkn1 VSS VSS nmos_rvt w=108.00n l=20n nfin=4
.ENDS

.SUBCKT ICGx6p67DC_ASAP7_75t_R CLK ENA GCLK SE VDD VSS
MM55 net0175 net0175 VDD VDD pmos_rvt w=162.00n l=20n nfin=6
MM54 net0175 net0212 VDD VDD pmos_rvt w=162.00n l=20n nfin=6
MM51 net0162 net0162 VDD VDD pmos_rvt w=162.00n l=20n nfin=6
MM47 gclkn2 CLK VDD VDD pmos_rvt w=108.00n l=20n nfin=4
MM46 gclkn2 MH VDD VDD pmos_rvt w=108.00n l=20n nfin=4
MM45 GCLK gclkn2 VDD VDD pmos_rvt w=108.00n l=20n nfin=4
MM18 nos1 SE VDD VDD pmos_rvt w=54.0n l=20n nfin=2
MM16 gclkn0 CLK VDD VDD pmos_rvt w=108.00n l=20n nfin=4
MM7 MS MH VDD VDD pmos_rvt w=27n l=20n nfin=1
MM11 pd2 MS VDD VDD pmos_rvt w=27n l=20n nfin=1
MM10 MH clkn pd2 VDD pmos_rvt w=27n l=20n nfin=1
MM25 GCLK gclkn0 VDD VDD pmos_rvt w=162.00n l=20n nfin=6
MM50 net0162 net0207 VDD VDD pmos_rvt w=162.00n l=20n nfin=6
MM1 MH CLK pu1 VDD pmos_rvt w=81.0n l=20n nfin=3
MM3 pu1 net0121 VDD VDD pmos_rvt w=81.0n l=20n nfin=3
MM21 clkn CLK VDD VDD pmos_rvt w=162.00n l=20n nfin=6
MM29 GCLK gclkn1 VDD VDD pmos_rvt w=162.00n l=20n nfin=6
MM30 gclkn1 MH VDD VDD pmos_rvt w=108.00n l=20n nfin=4
MM35 gclkn3 CLK VDD VDD pmos_rvt w=108.00n l=20n nfin=4
MM36 gclkn3 MH VDD VDD pmos_rvt w=108.00n l=20n nfin=4
MM37 GCLK gclkn3 VDD VDD pmos_rvt w=108.00n l=20n nfin=4
MM31 gclkn1 CLK VDD VDD pmos_rvt w=108.00n l=20n nfin=4
MM26 net0121 ENA nos1 VDD pmos_rvt w=54.0n l=20n nfin=2
MM0 gclkn0 MH VDD VDD pmos_rvt w=108.00n l=20n nfin=4
MM57 net0212 net0175 VSS VSS nmos_rvt w=162.00n l=20n nfin=6
MM56 net0212 net0212 VSS VSS nmos_rvt w=162.00n l=20n nfin=6
MM53 net0207 net0162 VSS VSS nmos_rvt w=162.00n l=20n nfin=6
MM52 net0207 net0207 VSS VSS nmos_rvt w=162.00n l=20n nfin=6
MM27 net0121 SE VSS VSS nmos_rvt w=54.0n l=20n nfin=2
MM13 gclkn0 CLK net0141 VSS nmos_rvt w=81.0n l=20n nfin=3
MM39 gclkn3 CLK net0244 VSS nmos_rvt w=81.0n l=20n nfin=3
MM6 MS MH VSS VSS nmos_rvt w=27.0n l=20n nfin=1
MM12 net0141 MH VSS VSS nmos_rvt w=81.0n l=20n nfin=3
MM40 net0243 MH VSS VSS nmos_rvt w=81.0n l=20n nfin=3
MM38 GCLK gclkn3 VSS VSS nmos_rvt w=108.00n l=20n nfin=4
MM14 net0140 MH VSS VSS nmos_rvt w=81.0n l=20n nfin=3
MM2 gclkn0 CLK net0140 VSS nmos_rvt w=81.0n l=20n nfin=3
MM19 net0121 ENA VSS VSS nmos_rvt w=54.0n l=20n nfin=2
MM9 MH CLK pd3 VSS nmos_rvt w=27.0n l=20n nfin=1
MM8 pd3 MS VSS VSS nmos_rvt w=27.0n l=20n nfin=1
MM15 net0247 MH VSS VSS nmos_rvt w=81.0n l=20n nfin=3
MM5 pd1 net0121 VSS VSS nmos_rvt w=81.0n l=20n nfin=3
MM4 MH clkn pd1 VSS nmos_rvt w=81.0n l=20n nfin=3
MM17 net0246 MH VSS VSS nmos_rvt w=81.0n l=20n nfin=3
MM22 gclkn1 CLK net0247 VSS nmos_rvt w=81.0n l=20n nfin=3
MM41 net0242 MH VSS VSS nmos_rvt w=81.0n l=20n nfin=3
MM42 gclkn2 CLK net0243 VSS nmos_rvt w=81.0n l=20n nfin=3
MM43 gclkn2 CLK net0242 VSS nmos_rvt w=81.0n l=20n nfin=3
MM32 net0245 MH VSS VSS nmos_rvt w=81.0n l=20n nfin=3
MM33 net0244 MH VSS VSS nmos_rvt w=81.0n l=20n nfin=3
MM20 clkn CLK VSS VSS nmos_rvt w=162.00n l=20n nfin=6
MM24 GCLK gclkn0 VSS VSS nmos_rvt w=162.00n l=20n nfin=6
MM23 gclkn1 CLK net0246 VSS nmos_rvt w=81.0n l=20n nfin=3
MM34 gclkn3 CLK net0245 VSS nmos_rvt w=81.0n l=20n nfin=3
MM44 GCLK gclkn2 VSS VSS nmos_rvt w=108.00n l=20n nfin=4
MM28 GCLK gclkn1 VSS VSS nmos_rvt w=162.00n l=20n nfin=6
.ENDS

.SUBCKT ICGx8DC_ASAP7_75t_R CLK ENA GCLK SE VDD VSS
MM55 net0175 net0175 VDD VDD pmos_rvt w=162.00n l=20n nfin=6
MM54 net0175 net0212 VDD VDD pmos_rvt w=162.00n l=20n nfin=6
MM51 net0162 net0162 VDD VDD pmos_rvt w=162.00n l=20n nfin=6
MM47 gclkn2 CLK VDD VDD pmos_rvt w=108.00n l=20n nfin=4
MM46 gclkn2 MH VDD VDD pmos_rvt w=108.00n l=20n nfin=4
MM45 GCLK gclkn2 VDD VDD pmos_rvt w=162.00n l=20n nfin=6
MM18 nos1 SE VDD VDD pmos_rvt w=54.0n l=20n nfin=2
MM16 gclkn0 CLK VDD VDD pmos_rvt w=108.00n l=20n nfin=4
MM7 MS MH VDD VDD pmos_rvt w=27n l=20n nfin=1
MM11 pd2 MS VDD VDD pmos_rvt w=27n l=20n nfin=1
MM10 MH clkn pd2 VDD pmos_rvt w=27n l=20n nfin=1
MM25 GCLK gclkn0 VDD VDD pmos_rvt w=162.00n l=20n nfin=6
MM50 net0162 net0207 VDD VDD pmos_rvt w=162.00n l=20n nfin=6
MM1 MH CLK pu1 VDD pmos_rvt w=81.0n l=20n nfin=3
MM3 pu1 net0121 VDD VDD pmos_rvt w=81.0n l=20n nfin=3
MM21 clkn CLK VDD VDD pmos_rvt w=162.00n l=20n nfin=6
MM29 GCLK gclkn1 VDD VDD pmos_rvt w=162.00n l=20n nfin=6
MM30 gclkn1 MH VDD VDD pmos_rvt w=108.00n l=20n nfin=4
MM35 gclkn3 CLK VDD VDD pmos_rvt w=108.00n l=20n nfin=4
MM36 gclkn3 MH VDD VDD pmos_rvt w=108.00n l=20n nfin=4
MM37 GCLK gclkn3 VDD VDD pmos_rvt w=162.00n l=20n nfin=6
MM31 gclkn1 CLK VDD VDD pmos_rvt w=108.00n l=20n nfin=4
MM26 net0121 ENA nos1 VDD pmos_rvt w=54.0n l=20n nfin=2
MM0 gclkn0 MH VDD VDD pmos_rvt w=108.00n l=20n nfin=4
MM57 net0212 net0175 VSS VSS nmos_rvt w=162.00n l=20n nfin=6
MM56 net0212 net0212 VSS VSS nmos_rvt w=162.00n l=20n nfin=6
MM53 net0207 net0162 VSS VSS nmos_rvt w=162.00n l=20n nfin=6
MM52 net0207 net0207 VSS VSS nmos_rvt w=162.00n l=20n nfin=6
MM27 net0121 SE VSS VSS nmos_rvt w=54.0n l=20n nfin=2
MM13 gclkn0 CLK net0141 VSS nmos_rvt w=81.0n l=20n nfin=3
MM39 gclkn3 CLK net0244 VSS nmos_rvt w=81.0n l=20n nfin=3
MM6 MS MH VSS VSS nmos_rvt w=27.0n l=20n nfin=1
MM12 net0141 MH VSS VSS nmos_rvt w=81.0n l=20n nfin=3
MM40 net0243 MH VSS VSS nmos_rvt w=81.0n l=20n nfin=3
MM38 GCLK gclkn3 VSS VSS nmos_rvt w=162.00n l=20n nfin=6
MM14 net0140 MH VSS VSS nmos_rvt w=81.0n l=20n nfin=3
MM2 gclkn0 CLK net0140 VSS nmos_rvt w=81.0n l=20n nfin=3
MM19 net0121 ENA VSS VSS nmos_rvt w=54.0n l=20n nfin=2
MM9 MH CLK pd3 VSS nmos_rvt w=27.0n l=20n nfin=1
MM8 pd3 MS VSS VSS nmos_rvt w=27.0n l=20n nfin=1
MM15 net0247 MH VSS VSS nmos_rvt w=81.0n l=20n nfin=3
MM5 pd1 net0121 VSS VSS nmos_rvt w=81.0n l=20n nfin=3
MM4 MH clkn pd1 VSS nmos_rvt w=81.0n l=20n nfin=3
MM17 net0246 MH VSS VSS nmos_rvt w=81.0n l=20n nfin=3
MM22 gclkn1 CLK net0247 VSS nmos_rvt w=81.0n l=20n nfin=3
MM41 net0242 MH VSS VSS nmos_rvt w=81.0n l=20n nfin=3
MM42 gclkn2 CLK net0243 VSS nmos_rvt w=81.0n l=20n nfin=3
MM43 gclkn2 CLK net0242 VSS nmos_rvt w=81.0n l=20n nfin=3
MM32 net0245 MH VSS VSS nmos_rvt w=81.0n l=20n nfin=3
MM33 net0244 MH VSS VSS nmos_rvt w=81.0n l=20n nfin=3
MM20 clkn CLK VSS VSS nmos_rvt w=162.00n l=20n nfin=6
MM24 GCLK gclkn0 VSS VSS nmos_rvt w=162.00n l=20n nfin=6
MM23 gclkn1 CLK net0246 VSS nmos_rvt w=81.0n l=20n nfin=3
MM34 gclkn3 CLK net0245 VSS nmos_rvt w=81.0n l=20n nfin=3
MM44 GCLK gclkn2 VSS VSS nmos_rvt w=162.00n l=20n nfin=6
MM28 GCLK gclkn1 VSS VSS nmos_rvt w=162.00n l=20n nfin=6
.ENDS

.SUBCKT INVx11_ASAP7_75t_R A VDD VSS Y
MM0 Y A VSS VSS nmos_rvt w=891.00n l=20n nfin=33
MM1 Y A VDD VDD pmos_rvt w=891.00n l=20n nfin=33
.ENDS

.SUBCKT INVx13_ASAP7_75t_R A VDD VSS Y
MM0 Y A VSS VSS nmos_rvt w=1.053u l=20n nfin=39
MM1 Y A VDD VDD pmos_rvt w=1.053u l=20n nfin=39
.ENDS

.SUBCKT INVx1_ASAP7_75t_R A VDD VSS Y
M0 Y A VSS VSS nmos_rvt L=2e-08 W=1.62e-07 nfin=3
M1 Y A VDD VDD pmos_rvt L=2e-08 W=8.1e-08 nfin=3
.ENDS

.SUBCKT INVx2_ASAP7_75t_R A VDD VSS Y
M0 Y A VSS VSS nmos_rvt L=2e-08 W=8.1e-08 nfin=3
M1 Y A VSS VSS nmos_rvt L=2e-08 W=8.1e-08 nfin=3
M2 Y A VDD VDD pmos_rvt L=2e-08 W=8.1e-08 nfin=3
M3 Y A VDD VDD pmos_rvt L=2e-08 W=8.1e-08 nfin=3
.ENDS

.SUBCKT INVx3_ASAP7_75t_R A VDD VSS Y
MM0 Y A VSS VSS nmos_rvt w=243.00n l=20n nfin=9
MM1 Y A VDD VDD pmos_rvt w=243.00n l=20n nfin=9
.ENDS

.SUBCKT INVx4_ASAP7_75t_R A VDD VSS Y
MM0 Y A VSS VSS nmos_rvt w=324.00n l=20n nfin=12
MM1 Y A VDD VDD pmos_rvt w=324.00n l=20n nfin=12
.ENDS

.SUBCKT INVx5_ASAP7_75t_R A VDD VSS Y
MM0 Y A VSS VSS nmos_rvt w=405.00n l=20n nfin=15
MM1 Y A VDD VDD pmos_rvt w=405.00n l=20n nfin=15
.ENDS

.SUBCKT INVx6_ASAP7_75t_R A VDD VSS Y
MM0 Y A VSS VSS nmos_rvt w=486.00n l=20n nfin=18
MM1 Y A VDD VDD pmos_rvt w=486.00n l=20n nfin=18
.ENDS

.SUBCKT INVx8_ASAP7_75t_R A VDD VSS Y
MM0 Y A VSS VSS nmos_rvt w=648.00n l=20n nfin=24
MM1 Y A VDD VDD pmos_rvt w=648.00n l=20n nfin=24
.ENDS

.SUBCKT INVxp33_ASAP7_75t_R A VDD VSS Y
MM0 Y A VSS VSS nmos_rvt w=27.0n l=20n nfin=1
MM1 Y A VDD VDD pmos_rvt w=27.0n l=20n nfin=1
.ENDS

.SUBCKT INVxp67_ASAP7_75t_R A VDD VSS Y
MM0 Y A VSS VSS nmos_rvt w=54.0n l=20n nfin=2
MM1 Y A VDD VDD pmos_rvt w=54.0n l=20n nfin=2
.ENDS

.SUBCKT MAJIxp5_ASAP7_75t_R A B C VDD VSS Y
MM4 net17 C VSS VSS nmos_rvt w=81.0n l=20n nfin=3
MM3 Y B net17 VSS nmos_rvt w=81.0n l=20n nfin=3
MM2 net1 C VSS VSS nmos_rvt w=81.0n l=20n nfin=3
MM1 net1 B VSS VSS nmos_rvt w=81.0n l=20n nfin=3
MM0 Y A net1 VSS nmos_rvt w=81.0n l=20n nfin=3
MM9 net16 C VDD VDD pmos_rvt w=81.0n l=20n nfin=3
MM8 Y B net16 VDD pmos_rvt w=81.0n l=20n nfin=3
MM7 net3 C VDD VDD pmos_rvt w=81.0n l=20n nfin=3
MM6 net3 B VDD VDD pmos_rvt w=81.0n l=20n nfin=3
MM5 Y A net3 VDD pmos_rvt w=81.0n l=20n nfin=3
.ENDS

.SUBCKT MAJx2_ASAP7_75t_R A B C VDD VSS Y
MM4 net17 C VSS VSS nmos_rvt w=81.0n l=20n nfin=3
MM3 maji B net17 VSS nmos_rvt w=81.0n l=20n nfin=3
MM2 net1 C VSS VSS nmos_rvt w=81.0n l=20n nfin=3
MM1 net1 B VSS VSS nmos_rvt w=81.0n l=20n nfin=3
MM0 maji A net1 VSS nmos_rvt w=81.0n l=20n nfin=3
MM10 Y maji VSS VSS nmos_rvt w=162.00n l=20n nfin=6
MM9 net16 C VDD VDD pmos_rvt w=81.0n l=20n nfin=3
MM8 maji B net16 VDD pmos_rvt w=81.0n l=20n nfin=3
MM7 net3 C VDD VDD pmos_rvt w=81.0n l=20n nfin=3
MM6 net3 B VDD VDD pmos_rvt w=81.0n l=20n nfin=3
MM5 maji A net3 VDD pmos_rvt w=81.0n l=20n nfin=3
MM11 Y maji VDD VDD pmos_rvt w=162.00n l=20n nfin=6
.ENDS

.SUBCKT MAJx3_ASAP7_75t_R A B C VDD VSS Y
MM4 net17 C VSS VSS nmos_rvt w=81.0n l=20n nfin=3
MM3 maji B net17 VSS nmos_rvt w=81.0n l=20n nfin=3
MM2 net1 C VSS VSS nmos_rvt w=81.0n l=20n nfin=3
MM1 net1 B VSS VSS nmos_rvt w=81.0n l=20n nfin=3
MM0 maji A net1 VSS nmos_rvt w=81.0n l=20n nfin=3
MM10 Y maji VSS VSS nmos_rvt w=243.00n l=20n nfin=9
MM9 net16 C VDD VDD pmos_rvt w=81.0n l=20n nfin=3
MM8 maji B net16 VDD pmos_rvt w=81.0n l=20n nfin=3
MM7 net3 C VDD VDD pmos_rvt w=81.0n l=20n nfin=3
MM6 net3 B VDD VDD pmos_rvt w=81.0n l=20n nfin=3
MM5 maji A net3 VDD pmos_rvt w=81.0n l=20n nfin=3
MM11 Y maji VDD VDD pmos_rvt w=243.00n l=20n nfin=9
.ENDS

.SUBCKT NAND2x1_ASAP7_75t_R A B VDD VSS Y
M0 VSS A N_M0_s VSS nmos_rvt L=2e-08 W=8.1e-08 nfin=3
M1 VSS A N_M0_s VSS nmos_rvt L=2e-08 W=8.1e-08 nfin=3
M2 Y B N_M0_s VSS nmos_rvt L=2e-08 W=8.1e-08 nfin=3
M3 Y B N_M0_s VSS nmos_rvt L=2e-08 W=8.1e-08 nfin=3
M4 VDD A Y VDD pmos_rvt L=2e-08 W=8.1e-08 nfin=3
M5 Y B VDD VDD pmos_rvt L=2e-08 W=8.1e-08 nfin=3
.ENDS

.SUBCKT NAND2x1p5_ASAP7_75t_R A B VDD VSS Y
MM3 net16 A VSS VSS nmos_rvt w=243.00n l=20n nfin=9
MM2 Y B net16 VSS nmos_rvt w=243.00n l=20n nfin=9
MM1 Y B VDD VDD pmos_rvt w=135.00n l=20n nfin=5
MM0 Y A VDD VDD pmos_rvt w=135.00n l=20n nfin=5
.ENDS

.SUBCKT NAND2x2_ASAP7_75t_R A B VDD VSS Y
MM3 net16 A VSS VSS nmos_rvt w=324.00n l=20n nfin=12
MM2 Y B net16 VSS nmos_rvt w=324.00n l=20n nfin=12
MM1 Y B VDD VDD pmos_rvt w=162.00n l=20n nfin=6
MM0 Y A VDD VDD pmos_rvt w=162.00n l=20n nfin=6
.ENDS

.SUBCKT NAND2xp33_ASAP7_75t_R A B VDD VSS Y
MM3 net16 A VSS VSS nmos_rvt w=54.0n l=20n nfin=2
MM2 Y B net16 VSS nmos_rvt w=54.0n l=20n nfin=2
MM1 Y B VDD VDD pmos_rvt w=27.0n l=20n nfin=1
MM0 Y A VDD VDD pmos_rvt w=27.0n l=20n nfin=1
.ENDS

.SUBCKT NAND2xp5_ASAP7_75t_R A B VDD VSS Y
MM3 net16 A VSS VSS nmos_rvt w=81.0n l=20n nfin=3
MM2 Y B net16 VSS nmos_rvt w=81.0n l=20n nfin=3
MM1 Y B VDD VDD pmos_rvt w=54.0n l=20n nfin=2
MM0 Y A VDD VDD pmos_rvt w=54.0n l=20n nfin=2
.ENDS

.SUBCKT NAND2xp67_ASAP7_75t_R A B VDD VSS Y
MM4 net15 A VSS VSS nmos_rvt w=108.00n l=20n nfin=4
MM3 Y B net15 VSS nmos_rvt w=108.00n l=20n nfin=4
MM5 Y B VDD VDD pmos_rvt w=54.0n l=20n nfin=2
MM2 Y A VDD VDD pmos_rvt w=54.0n l=20n nfin=2
.ENDS

.SUBCKT NAND3x1_ASAP7_75t_R A B C VDD VSS Y
MM0 Y A net22 VSS nmos_rvt w=243.00n l=20n nfin=9
MM1 net22 B net21 VSS nmos_rvt w=243.00n l=20n nfin=9
MM2 net21 C VSS VSS nmos_rvt w=243.00n l=20n nfin=9
MM3 Y A VDD VDD pmos_rvt w=81.0n l=20n nfin=3
MM4 Y B VDD VDD pmos_rvt w=81.0n l=20n nfin=3
MM5 Y C VDD VDD pmos_rvt w=81.0n l=20n nfin=3
.ENDS

.SUBCKT NAND3x2_ASAP7_75t_R A B C VDD VSS Y
MM0 Y A net22 VSS nmos_rvt w=486.00n l=20n nfin=18
MM1 net22 B net21 VSS nmos_rvt w=486.00n l=20n nfin=18
MM2 net21 C VSS VSS nmos_rvt w=486.00n l=20n nfin=18
MM3 Y A VDD VDD pmos_rvt w=162.00n l=20n nfin=6
MM4 Y B VDD VDD pmos_rvt w=162.00n l=20n nfin=6
MM5 Y C VDD VDD pmos_rvt w=162.00n l=20n nfin=6
.ENDS

.SUBCKT NAND3xp33_ASAP7_75t_R A B C VDD VSS Y
MM0 Y A net22 VSS nmos_rvt w=81.0n l=20n nfin=3
MM1 net22 B net21 VSS nmos_rvt w=81.0n l=20n nfin=3
MM2 net21 C VSS VSS nmos_rvt w=81.0n l=20n nfin=3
MM3 Y A VDD VDD pmos_rvt w=54.0n l=20n nfin=2
MM4 Y B VDD VDD pmos_rvt w=54.0n l=20n nfin=2
MM5 Y C VDD VDD pmos_rvt w=54.0n l=20n nfin=2
.ENDS

.SUBCKT NAND4xp25_ASAP7_75t_R A B C D VDD VSS Y
MM5 pd3 D VSS VSS nmos_rvt w=81.0n l=20n nfin=3
MM3 pd2 C pd3 VSS nmos_rvt w=81.0n l=20n nfin=3
MM4 pd1 B pd2 VSS nmos_rvt w=81.0n l=20n nfin=3
MM0 Y A pd1 VSS nmos_rvt w=81.0n l=20n nfin=3
MM7 Y D VDD VDD pmos_rvt w=54.0n l=20n nfin=2
MM6 Y C VDD VDD pmos_rvt w=54.0n l=20n nfin=2
MM2 Y B VDD VDD pmos_rvt w=54.0n l=20n nfin=2
MM1 Y A VDD VDD pmos_rvt w=54.0n l=20n nfin=2
.ENDS

.SUBCKT NAND4xp75_ASAP7_75t_R A B C D VDD VSS Y
MM5 pd3 D VSS VSS nmos_rvt w=243.00n l=20n nfin=9
MM3 pd2 C pd3 VSS nmos_rvt w=243.00n l=20n nfin=9
MM4 pd1 B pd2 VSS nmos_rvt w=243.00n l=20n nfin=9
MM0 Y A pd1 VSS nmos_rvt w=243.00n l=20n nfin=9
MM7 Y D VDD VDD pmos_rvt w=162.00n l=20n nfin=6
MM6 Y C VDD VDD pmos_rvt w=162.00n l=20n nfin=6
MM2 Y B VDD VDD pmos_rvt w=162.00n l=20n nfin=6
MM1 Y A VDD VDD pmos_rvt w=162.00n l=20n nfin=6
.ENDS

.SUBCKT NAND5xp2_ASAP7_75t_R A B C D E VDD VSS Y
MM6 net29 E VSS VSS nmos_rvt w=81.0n l=20n nfin=3
MM5 net30 D net29 VSS nmos_rvt w=81.0n l=20n nfin=3
MM4 net024 B net023 VSS nmos_rvt w=81.0n l=20n nfin=3
MM0 Y A net024 VSS nmos_rvt w=81.0n l=20n nfin=3
MM3 net023 C net30 VSS nmos_rvt w=81.0n l=20n nfin=3
MM9 Y E VDD VDD pmos_rvt w=54.0n l=20n nfin=2
MM8 Y D VDD VDD pmos_rvt w=54.0n l=20n nfin=2
MM7 Y C VDD VDD pmos_rvt w=54.0n l=20n nfin=2
MM2 Y B VDD VDD pmos_rvt w=54.0n l=20n nfin=2
MM10 Y A VDD VDD pmos_rvt w=54.0n l=20n nfin=2
.ENDS

.SUBCKT NOR2x1_ASAP7_75t_R A B VDD VSS Y
M0 VSS A Y VSS nmos_rvt L=2e-08 W=8.1e-08 nfin=3
M1 Y B VSS VSS nmos_rvt L=2e-08 W=8.1e-08 nfin=3
M2 VDD A N_M2_s VDD pmos_rvt L=2e-08 W=8.1e-08 nfin=3
M3 VDD A N_M2_s VDD pmos_rvt L=2e-08 W=8.1e-08 nfin=3
M4 Y B N_M2_s VDD pmos_rvt L=2e-08 W=8.1e-08 nfin=3
M5 Y B N_M2_s VDD pmos_rvt L=2e-08 W=8.1e-08 nfin=3
.ENDS

.SUBCKT NOR2x1p5_ASAP7_75t_R A B VDD VSS Y
MM2 VSS A Y VSS nmos_rvt w=135.00n l=20n nfin=5
MM1 VSS B Y VSS nmos_rvt w=135.00n l=20n nfin=5
MM4 net16 B Y VDD pmos_rvt w=243.00n l=20n nfin=9
MM3 VDD A net16 VDD pmos_rvt w=243.00n l=20n nfin=9
.ENDS

.SUBCKT NOR2x2_ASAP7_75t_R A B VDD VSS Y
MM2 VSS A Y VSS nmos_rvt w=162.00n l=20n nfin=6
MM1 VSS B Y VSS nmos_rvt w=162.00n l=20n nfin=6
MM4 net16 B Y VDD pmos_rvt w=324.00n l=20n nfin=12
MM3 VDD A net16 VDD pmos_rvt w=324.00n l=20n nfin=12
.ENDS

.SUBCKT NOR2xp33_ASAP7_75t_R A B VDD VSS Y
MM2 VSS A Y VSS nmos_rvt w=27.0n l=20n nfin=1
MM1 VSS B Y VSS nmos_rvt w=27.0n l=20n nfin=1
MM4 net16 B Y VDD pmos_rvt w=54.0n l=20n nfin=2
MM3 VDD A net16 VDD pmos_rvt w=54.0n l=20n nfin=2
.ENDS

.SUBCKT NOR2xp67_ASAP7_75t_R A B VDD VSS Y
MM2 VSS A Y VSS nmos_rvt w=54.0n l=20n nfin=2
MM1 VSS B Y VSS nmos_rvt w=54.0n l=20n nfin=2
MM4 net16 B Y VDD pmos_rvt w=108.00n l=20n nfin=4
MM3 VDD A net16 VDD pmos_rvt w=108.00n l=20n nfin=4
.ENDS

.SUBCKT NOR3x1_ASAP7_75t_R A B C VDD VSS Y
M0 Y C VSS VSS nmos_rvt L=2e-08 W=8.1e-08 nfin=3
M1 VSS B Y VSS nmos_rvt L=2e-08 W=8.1e-08 nfin=3
M2 Y A VSS VSS nmos_rvt L=2e-08 W=8.1e-08 nfin=3
M3 N_M3_d C VDD VDD pmos_rvt L=2e-08 W=8.1e-08 nfin=3
M4 N_M3_d C VDD VDD pmos_rvt L=2e-08 W=8.1e-08 nfin=3
M5 N_M3_d C VDD VDD pmos_rvt L=2e-08 W=8.1e-08 nfin=3
M6 N_M6_d B N_M3_d VDD pmos_rvt L=2e-08 W=8.1e-08 nfin=3
M7 N_M6_d B N_M3_d VDD pmos_rvt L=2e-08 W=8.1e-08 nfin=3
M8 N_M6_d B N_M3_d VDD pmos_rvt L=2e-08 W=8.1e-08 nfin=3
M9 Y A N_M6_d VDD pmos_rvt L=2e-08 W=8.1e-08 nfin=3
M10 Y A N_M6_d VDD pmos_rvt L=2e-08 W=8.1e-08 nfin=3
M11 Y A N_M6_d VDD pmos_rvt L=2e-08 W=8.1e-08 nfin=3
.ENDS

.SUBCKT NOR3x2_ASAP7_75t_R A B C VDD VSS Y
MM14 Y C VSS VSS nmos_rvt w=162.00n l=20n nfin=6
MM13 Y B VSS VSS nmos_rvt w=162.00n l=20n nfin=6
MM12 Y A VSS VSS nmos_rvt w=162.00n l=20n nfin=6
MM8 net21 C VDD VDD pmos_rvt w=486.00n l=20n nfin=18
MM10 net22 B net21 VDD pmos_rvt w=486.00n l=20n nfin=18
MM11 Y A net22 VDD pmos_rvt w=486.00n l=20n nfin=18
.ENDS

.SUBCKT NOR3xp33_ASAP7_75t_R A B C VDD VSS Y
MM14 Y C VSS VSS nmos_rvt w=54.0n l=20n nfin=2
MM13 Y B VSS VSS nmos_rvt w=54.0n l=20n nfin=2
MM12 Y A VSS VSS nmos_rvt w=54.0n l=20n nfin=2
MM8 net21 C VDD VDD pmos_rvt w=81.0n l=20n nfin=3
MM10 net22 B net21 VDD pmos_rvt w=81.0n l=20n nfin=3
MM11 Y A net22 VDD pmos_rvt w=81.0n l=20n nfin=3
.ENDS

.SUBCKT NOR4xp25_ASAP7_75t_R A B C D VDD VSS Y
MM7 Y A pd1 VDD pmos_rvt w=81.0n l=20n nfin=3
MM6 pd1 B pd2 VDD pmos_rvt w=81.0n l=20n nfin=3
MM5 pd2 C pd3 VDD pmos_rvt w=81.0n l=20n nfin=3
MM4 pd3 D VDD VDD pmos_rvt w=81.0n l=20n nfin=3
MM3 Y D VSS VSS nmos_rvt w=54.0n l=20n nfin=2
MM2 Y C VSS VSS nmos_rvt w=54.0n l=20n nfin=2
MM1 Y B VSS VSS nmos_rvt w=54.0n l=20n nfin=2
MM0 Y A VSS VSS nmos_rvt w=54.0n l=20n nfin=2
.ENDS

.SUBCKT NOR4xp75_ASAP7_75t_R A B C D VDD VSS Y
MM7 Y A pd1 VDD pmos_rvt w=243.00n l=20n nfin=9
MM6 pd1 B pd2 VDD pmos_rvt w=243.00n l=20n nfin=9
MM5 pd2 C pd3 VDD pmos_rvt w=243.00n l=20n nfin=9
MM4 pd3 D VDD VDD pmos_rvt w=243.00n l=20n nfin=9
MM3 Y D VSS VSS nmos_rvt w=162.00n l=20n nfin=6
MM2 Y C VSS VSS nmos_rvt w=162.00n l=20n nfin=6
MM1 Y B VSS VSS nmos_rvt w=162.00n l=20n nfin=6
MM0 Y A VSS VSS nmos_rvt w=162.00n l=20n nfin=6
.ENDS

.SUBCKT NOR5xp2_ASAP7_75t_R A B C D E VDD VSS Y
MM9 Y A net024 VDD pmos_rvt w=81.0n l=20n nfin=3
MM8 net024 B net023 VDD pmos_rvt w=81.0n l=20n nfin=3
MM6 net30 D net29 VDD pmos_rvt w=81.0n l=20n nfin=3
MM5 net29 E VDD VDD pmos_rvt w=81.0n l=20n nfin=3
MM7 net023 C net30 VDD pmos_rvt w=81.0n l=20n nfin=3
MM4 Y E VSS VSS nmos_rvt w=54.0n l=20n nfin=2
MM3 Y D VSS VSS nmos_rvt w=54.0n l=20n nfin=2
MM2 Y C VSS VSS nmos_rvt w=54.0n l=20n nfin=2
MM1 Y B VSS VSS nmos_rvt w=54.0n l=20n nfin=2
MM0 Y A VSS VSS nmos_rvt w=54.0n l=20n nfin=2
.ENDS

.SUBCKT O2A1O1Ixp33_ASAP7_75t_R A1 A2 B C VDD VSS Y
MM7 net010 B VDD VDD pmos_rvt w=81.0n l=20n nfin=3
MM6 Y C net010 VDD pmos_rvt w=81.0n l=20n nfin=3
MM5 net010 A2 net019 VDD pmos_rvt w=81.0n l=20n nfin=3
MM4 net019 A1 VDD VDD pmos_rvt w=81.0n l=20n nfin=3
MM3 Y C VSS VSS nmos_rvt w=54.0n l=20n nfin=2
MM2 net022 B VSS VSS nmos_rvt w=81.0n l=20n nfin=3
MM1 Y A2 net022 VSS nmos_rvt w=81.0n l=20n nfin=3
MM0 Y A1 net022 VSS nmos_rvt w=81.0n l=20n nfin=3
.ENDS

.SUBCKT O2A1O1Ixp5_ASAP7_75t_R A1 A2 B C VDD VSS Y
MM9 Y B net011 VSS nmos_rvt w=81.0n l=20n nfin=3
MM4 Y C VSS VSS nmos_rvt w=54.0n l=20n nfin=2
MM1 net011 A2 VSS VSS nmos_rvt w=81.0n l=20n nfin=3
MM0 net011 A1 VSS VSS nmos_rvt w=81.0n l=20n nfin=3
MM8 net03 B VDD VDD pmos_rvt w=81.0n l=20n nfin=3
MM7 net010 A1 VDD VDD pmos_rvt w=162.00n l=20n nfin=6
MM6 net03 A2 net010 VDD pmos_rvt w=162.00n l=20n nfin=6
MM5 Y C net03 VDD pmos_rvt w=81.0n l=20n nfin=3
.ENDS

.SUBCKT OA211x2_ASAP7_75t_R A1 A2 B C VDD VSS Y
M0 N_M0_d A2 noxref_8 VSS nmos_rvt L=2e-08 W=8.1e-08 nfin=3
M1 noxref_8 A1 N_M0_d VSS nmos_rvt L=2e-08 W=8.1e-08 nfin=3
M2 noxref_10 B noxref_8 VSS nmos_rvt L=2e-08 W=8.1e-08 nfin=3
M3 VSS C noxref_10 VSS nmos_rvt L=2e-08 W=8.1e-08 nfin=3
M4 Y N_M0_d VSS VSS nmos_rvt L=2e-08 W=8.1e-08 nfin=3
M5 Y N_M0_d VSS VSS nmos_rvt L=2e-08 W=8.1e-08 nfin=3
M6 noxref_11 A2 N_M0_d VDD pmos_rvt L=2e-08 W=5.4e-08 nfin=2
M7 VDD A1 noxref_11 VDD pmos_rvt L=2e-08 W=5.4e-08 nfin=2
M8 N_M0_d B VDD VDD pmos_rvt L=2e-08 W=2.7e-08 nfin=1
M9 VDD C N_M0_d VDD pmos_rvt L=2e-08 W=2.7e-08 nfin=1
M10 Y N_M0_d VDD VDD pmos_rvt L=2e-08 W=8.1e-08 nfin=3
M11 Y N_M0_d VDD VDD pmos_rvt L=2e-08 W=8.1e-08 nfin=3
.ENDS

.SUBCKT OA21x2_ASAP7_75t_R A1 A2 B VDD VSS Y
M0 N_M0_d A1 noxref_7 VSS nmos_rvt L=2e-08 W=8.1e-08 nfin=3
M1 noxref_7 A2 N_M0_d VSS nmos_rvt L=2e-08 W=8.1e-08 nfin=3
M2 VSS B noxref_7 VSS nmos_rvt L=2e-08 W=8.1e-08 nfin=3
M3 Y N_M0_d VSS VSS nmos_rvt L=2e-08 W=8.1e-08 nfin=3
M4 Y N_M0_d VSS VSS nmos_rvt L=2e-08 W=8.1e-08 nfin=3
M5 noxref_9 A1 VDD VDD pmos_rvt L=2e-08 W=8.1e-08 nfin=3
M6 N_M0_d A2 noxref_9 VDD pmos_rvt L=2e-08 W=8.1e-08 nfin=3
M7 VDD B N_M0_d VDD pmos_rvt L=2e-08 W=8.1e-08 nfin=3
M8 Y N_M0_d VDD VDD pmos_rvt L=2e-08 W=8.1e-08 nfin=3
M9 Y N_M0_d VDD VDD pmos_rvt L=2e-08 W=8.1e-08 nfin=3
.ENDS

.SUBCKT OA221x2_ASAP7_75t_R A1 A2 B1 B2 C VDD VSS Y
MM11 net15 B2 net29 VSS nmos_rvt w=162.00n l=20n nfin=6
MM10 net29 A2 VSS VSS nmos_rvt w=162.00n l=20n nfin=6
MM9 net29 A1 VSS VSS nmos_rvt w=162.00n l=20n nfin=6
MM6 net15 B1 net29 VSS nmos_rvt w=162.00n l=20n nfin=6
MM12 net014 C net15 VSS nmos_rvt w=162.00n l=20n nfin=6
MM24 Y net014 VSS VSS nmos_rvt w=162.00n l=20n nfin=6
MM4 net014 C VDD VDD pmos_rvt w=54.0n l=20n nfin=2
MM3 net014 B2 net32 VDD pmos_rvt w=81.0n l=20n nfin=3
MM2 net32 B1 VDD VDD pmos_rvt w=81.0n l=20n nfin=3
MM1 net014 A2 net30 VDD pmos_rvt w=81.0n l=20n nfin=3
MM0 net30 A1 VDD VDD pmos_rvt w=81.0n l=20n nfin=3
MM25 Y net014 VDD VDD pmos_rvt w=162.00n l=20n nfin=6
.ENDS

.SUBCKT OA222x2_ASAP7_75t_R A1 A2 B1 B2 C1 C2 VDD VSS Y
MM7 net28 C2 VDD VDD pmos_rvt w=81.0n l=20n nfin=3
MM6 net014 C1 net28 VDD pmos_rvt w=81.0n l=20n nfin=3
MM5 net014 B1 net29 VDD pmos_rvt w=81.0n l=20n nfin=3
MM4 net29 B2 VDD VDD pmos_rvt w=81.0n l=20n nfin=3
MM3 net014 A1 net30 VDD pmos_rvt w=81.0n l=20n nfin=3
MM2 net30 A2 VDD VDD pmos_rvt w=81.0n l=20n nfin=3
MM1 Y net014 VDD VDD pmos_rvt w=162.00n l=20n nfin=6
MM13 net010 C2 VSS VSS nmos_rvt w=81.0n l=20n nfin=3
MM12 net011 B2 net010 VSS nmos_rvt w=81.0n l=20n nfin=3
MM11 net014 A2 net011 VSS nmos_rvt w=81.0n l=20n nfin=3
MM10 net010 C1 VSS VSS nmos_rvt w=81.0n l=20n nfin=3
MM9 net011 B1 net010 VSS nmos_rvt w=81.0n l=20n nfin=3
MM8 net014 A1 net011 VSS nmos_rvt w=81.0n l=20n nfin=3
MM0 Y net014 VSS VSS nmos_rvt w=162.00n l=20n nfin=6
.ENDS

.SUBCKT OA22x2_ASAP7_75t_R A1 A2 B1 B2 VDD VSS Y
MM9 Y net033 VSS VSS nmos_rvt w=162.00n l=20n nfin=6
MM3 net3 B2 VSS VSS nmos_rvt w=81.0n l=20n nfin=3
MM2 net033 A2 net3 VSS nmos_rvt w=81.0n l=20n nfin=3
MM1 net3 B1 VSS VSS nmos_rvt w=81.0n l=20n nfin=3
MM0 net033 A1 net3 VSS nmos_rvt w=81.0n l=20n nfin=3
MM8 net13 A1 VDD VDD pmos_rvt w=81.0n l=20n nfin=3
MM11 net033 A2 net13 VDD pmos_rvt w=81.0n l=20n nfin=3
MM6 net14 B1 VDD VDD pmos_rvt w=81.0n l=20n nfin=3
MM5 Y net033 VDD VDD pmos_rvt w=162.00n l=20n nfin=6
MM10 net033 B2 net14 VDD pmos_rvt w=81.0n l=20n nfin=3
.ENDS

.SUBCKT OA31x2_ASAP7_75t_R A1 A2 A3 B1 VDD VSS Y
M0 noxref_9 A1 N_M0_s VSS nmos_rvt L=2e-08 W=8.1e-08 nfin=3
M1 N_M0_s A2 noxref_9 VSS nmos_rvt L=2e-08 W=8.1e-08 nfin=3
M2 noxref_9 A3 N_M0_s VSS nmos_rvt L=2e-08 W=8.1e-08 nfin=3
M3 VSS B1 noxref_9 VSS nmos_rvt L=2e-08 W=8.1e-08 nfin=3
M4 Y N_M0_s VSS VSS nmos_rvt L=2e-08 W=8.1e-08 nfin=3
M5 Y N_M0_s VSS VSS nmos_rvt L=2e-08 W=8.1e-08 nfin=3
M6 VDD A1 noxref_8 VDD pmos_rvt L=2e-08 W=8.1e-08 nfin=3
M7 VDD A1 noxref_8 VDD pmos_rvt L=2e-08 W=8.1e-08 nfin=3
M8 noxref_10 A2 noxref_8 VDD pmos_rvt L=2e-08 W=8.1e-08 nfin=3
M9 noxref_10 A2 noxref_8 VDD pmos_rvt L=2e-08 W=8.1e-08 nfin=3
M10 noxref_10 A3 N_M0_s VDD pmos_rvt L=2e-08 W=8.1e-08 nfin=3
M11 noxref_10 A3 N_M0_s VDD pmos_rvt L=2e-08 W=8.1e-08 nfin=3
M12 VDD B1 N_M0_s VDD pmos_rvt L=2e-08 W=5.4e-08 nfin=2
M13 Y N_M0_s VDD VDD pmos_rvt L=2e-08 W=8.1e-08 nfin=3
M14 Y N_M0_s VDD VDD pmos_rvt L=2e-08 W=8.1e-08 nfin=3
.ENDS

.SUBCKT OA331x1_ASAP7_75t_R A1 A2 A3 B1 B2 B3 C1 VDD VSS Y
MM4 net012 B3 net031 VSS nmos_rvt w=81.0n l=20n nfin=3
MM18 VSS net027 Y VSS nmos_rvt w=81.0n l=20n nfin=3
MM9 VSS A1 net012 VSS nmos_rvt w=81.0n l=20n nfin=3
MM8 VSS A2 net012 VSS nmos_rvt w=81.0n l=20n nfin=3
MM7 VSS A3 net012 VSS nmos_rvt w=81.0n l=20n nfin=3
MM6 net012 B1 net031 VSS nmos_rvt w=81.0n l=20n nfin=3
MM1 net031 C1 net027 VSS nmos_rvt w=81.0n l=20n nfin=3
MM5 net012 B2 net031 VSS nmos_rvt w=81.0n l=20n nfin=3
MM17 VDD C1 net027 VDD pmos_rvt w=81.0n l=20n nfin=3
MM12 net033 B1 net027 VDD pmos_rvt w=81.0n l=20n nfin=3
MM11 net063 B2 net033 VDD pmos_rvt w=81.0n l=20n nfin=3
MM10 VDD B3 net063 VDD pmos_rvt w=81.0n l=20n nfin=3
MM3 VDD A3 net26 VDD pmos_rvt w=81.0n l=20n nfin=3
MM14 net037 A1 net027 VDD pmos_rvt w=81.0n l=20n nfin=3
MM2 net26 A2 net037 VDD pmos_rvt w=81.0n l=20n nfin=3
MM19 VDD net027 Y VDD pmos_rvt w=81.0n l=20n nfin=3
.ENDS

.SUBCKT OA331x2_ASAP7_75t_R A1 A2 A3 B1 B2 B3 C1 VDD VSS Y
MM4 net012 B3 net031 VSS nmos_rvt w=81.0n l=20n nfin=3
MM18 VSS net027 Y VSS nmos_rvt w=162.00n l=20n nfin=6
MM9 VSS A1 net012 VSS nmos_rvt w=81.0n l=20n nfin=3
MM8 VSS A2 net012 VSS nmos_rvt w=81.0n l=20n nfin=3
MM7 VSS A3 net012 VSS nmos_rvt w=81.0n l=20n nfin=3
MM6 net012 B1 net031 VSS nmos_rvt w=81.0n l=20n nfin=3
MM1 net031 C1 net027 VSS nmos_rvt w=81.0n l=20n nfin=3
MM5 net012 B2 net031 VSS nmos_rvt w=81.0n l=20n nfin=3
MM17 VDD C1 net027 VDD pmos_rvt w=81.0n l=20n nfin=3
MM12 net033 B1 net027 VDD pmos_rvt w=81.0n l=20n nfin=3
MM11 net063 B2 net033 VDD pmos_rvt w=81.0n l=20n nfin=3
MM10 VDD B3 net063 VDD pmos_rvt w=81.0n l=20n nfin=3
MM3 VDD A3 net26 VDD pmos_rvt w=81.0n l=20n nfin=3
MM14 net037 A1 net027 VDD pmos_rvt w=81.0n l=20n nfin=3
MM2 net26 A2 net037 VDD pmos_rvt w=81.0n l=20n nfin=3
MM19 VDD net027 Y VDD pmos_rvt w=162.00n l=20n nfin=6
.ENDS

.SUBCKT OA332x1_ASAP7_75t_R A1 A2 A3 B1 B2 B3 C1 C2 VDD VSS Y
MM4 net059 B3 net060 VSS nmos_rvt w=81.0n l=20n nfin=3
MM18 VSS net027 Y VSS nmos_rvt w=81.0n l=20n nfin=3
MM9 VSS A1 net059 VSS nmos_rvt w=81.0n l=20n nfin=3
MM8 VSS A2 net059 VSS nmos_rvt w=81.0n l=20n nfin=3
MM7 VSS A3 net059 VSS nmos_rvt w=81.0n l=20n nfin=3
MM6 net059 B1 net060 VSS nmos_rvt w=81.0n l=20n nfin=3
MM0 net060 C2 net027 VSS nmos_rvt w=81.0n l=20n nfin=3
MM1 net060 C1 net027 VSS nmos_rvt w=81.0n l=20n nfin=3
MM5 net059 B2 net060 VSS nmos_rvt w=81.0n l=20n nfin=3
MM10 VDD B3 net080 VDD pmos_rvt w=81.0n l=20n nfin=3
MM3 VDD A3 net079 VDD pmos_rvt w=81.0n l=20n nfin=3
MM12 net081 B1 net027 VDD pmos_rvt w=81.0n l=20n nfin=3
MM11 net080 B2 net081 VDD pmos_rvt w=81.0n l=20n nfin=3
MM16 VDD C2 net082 VDD pmos_rvt w=81.0n l=20n nfin=3
MM2 net079 A2 net078 VDD pmos_rvt w=81.0n l=20n nfin=3
MM14 net078 A1 net027 VDD pmos_rvt w=81.0n l=20n nfin=3
MM17 net082 C1 net027 VDD pmos_rvt w=81.0n l=20n nfin=3
MM19 VDD net027 Y VDD pmos_rvt w=81.0n l=20n nfin=3
.ENDS

.SUBCKT OA332x2_ASAP7_75t_R A1 A2 A3 B1 B2 B3 C1 C2 VDD VSS Y
MM4 net059 B3 net060 VSS nmos_rvt w=81.0n l=20n nfin=3
MM18 VSS net027 Y VSS nmos_rvt w=162.00n l=20n nfin=6
MM9 VSS A1 net059 VSS nmos_rvt w=81.0n l=20n nfin=3
MM8 VSS A2 net059 VSS nmos_rvt w=81.0n l=20n nfin=3
MM7 VSS A3 net059 VSS nmos_rvt w=81.0n l=20n nfin=3
MM6 net059 B1 net060 VSS nmos_rvt w=81.0n l=20n nfin=3
MM0 net060 C2 net027 VSS nmos_rvt w=81.0n l=20n nfin=3
MM1 net060 C1 net027 VSS nmos_rvt w=81.0n l=20n nfin=3
MM5 net059 B2 net060 VSS nmos_rvt w=81.0n l=20n nfin=3
MM10 VDD B3 net080 VDD pmos_rvt w=81.0n l=20n nfin=3
MM3 VDD A3 net079 VDD pmos_rvt w=81.0n l=20n nfin=3
MM12 net081 B1 net027 VDD pmos_rvt w=81.0n l=20n nfin=3
MM11 net080 B2 net081 VDD pmos_rvt w=81.0n l=20n nfin=3
MM16 VDD C2 net082 VDD pmos_rvt w=81.0n l=20n nfin=3
MM2 net079 A2 net078 VDD pmos_rvt w=81.0n l=20n nfin=3
MM14 net078 A1 net027 VDD pmos_rvt w=81.0n l=20n nfin=3
MM17 net082 C1 net027 VDD pmos_rvt w=81.0n l=20n nfin=3
MM19 VDD net027 Y VDD pmos_rvt w=162.00n l=20n nfin=6
.ENDS

.SUBCKT OA333x1_ASAP7_75t_R A1 A2 A3 B1 B2 B3 C1 C2 C3 VDD VSS Y
MM19 VDD net020 Y VDD pmos_rvt w=81.0n l=20n nfin=3
MM13 VDD C3 net040 VDD pmos_rvt w=81.0n l=20n nfin=3
MM14 net084 A1 net020 VDD pmos_rvt w=81.0n l=20n nfin=3
MM16 net040 C2 net086 VDD pmos_rvt w=81.0n l=20n nfin=3
MM12 net087 B1 net020 VDD pmos_rvt w=81.0n l=20n nfin=3
MM11 net041 B2 net087 VDD pmos_rvt w=81.0n l=20n nfin=3
MM17 net086 C1 net020 VDD pmos_rvt w=81.0n l=20n nfin=3
MM3 VDD A3 net038 VDD pmos_rvt w=81.0n l=20n nfin=3
MM10 VDD B3 net041 VDD pmos_rvt w=81.0n l=20n nfin=3
MM2 net038 A2 net084 VDD pmos_rvt w=81.0n l=20n nfin=3
MM18 VSS net020 Y VSS nmos_rvt w=81.0n l=20n nfin=3
MM4 net068 B3 net015 VSS nmos_rvt w=81.0n l=20n nfin=3
MM1 net015 A1 net020 VSS nmos_rvt w=81.0n l=20n nfin=3
MM8 VSS C2 net068 VSS nmos_rvt w=81.0n l=20n nfin=3
MM9 VSS C1 net068 VSS nmos_rvt w=81.0n l=20n nfin=3
MM6 net068 B1 net015 VSS nmos_rvt w=81.0n l=20n nfin=3
MM7 VSS C3 net068 VSS nmos_rvt w=81.0n l=20n nfin=3
MM15 net015 A3 net020 VSS nmos_rvt w=81.0n l=20n nfin=3
MM5 net068 B2 net015 VSS nmos_rvt w=81.0n l=20n nfin=3
MM0 net015 A2 net020 VSS nmos_rvt w=81.0n l=20n nfin=3
.ENDS

.SUBCKT OA333x2_ASAP7_75t_R A1 A2 A3 B1 B2 B3 C1 C2 C3 VDD VSS Y
MM19 VDD net020 Y VDD pmos_rvt w=162.00n l=20n nfin=6
MM13 VDD C3 net040 VDD pmos_rvt w=81.0n l=20n nfin=3
MM14 net084 A1 net020 VDD pmos_rvt w=81.0n l=20n nfin=3
MM16 net040 C2 net086 VDD pmos_rvt w=81.0n l=20n nfin=3
MM12 net087 B1 net020 VDD pmos_rvt w=81.0n l=20n nfin=3
MM11 net041 B2 net087 VDD pmos_rvt w=81.0n l=20n nfin=3
MM17 net086 C1 net020 VDD pmos_rvt w=81.0n l=20n nfin=3
MM3 VDD A3 net038 VDD pmos_rvt w=81.0n l=20n nfin=3
MM10 VDD B3 net041 VDD pmos_rvt w=81.0n l=20n nfin=3
MM2 net038 A2 net084 VDD pmos_rvt w=81.0n l=20n nfin=3
MM18 VSS net020 Y VSS nmos_rvt w=162.00n l=20n nfin=6
MM4 net068 B3 net015 VSS nmos_rvt w=81.0n l=20n nfin=3
MM1 net015 A1 net020 VSS nmos_rvt w=81.0n l=20n nfin=3
MM8 VSS C2 net068 VSS nmos_rvt w=81.0n l=20n nfin=3
MM9 VSS C1 net068 VSS nmos_rvt w=81.0n l=20n nfin=3
MM6 net068 B1 net015 VSS nmos_rvt w=81.0n l=20n nfin=3
MM7 VSS C3 net068 VSS nmos_rvt w=81.0n l=20n nfin=3
MM15 net015 A3 net020 VSS nmos_rvt w=81.0n l=20n nfin=3
MM5 net068 B2 net015 VSS nmos_rvt w=81.0n l=20n nfin=3
MM0 net015 A2 net020 VSS nmos_rvt w=81.0n l=20n nfin=3
.ENDS

.SUBCKT OA33x2_ASAP7_75t_R A1 A2 A3 B1 B2 B3 VDD VSS Y
MM7 Y net015 VSS VSS nmos_rvt w=162.00n l=20n nfin=6
MM5 net21 A3 VSS VSS nmos_rvt w=81.0n l=20n nfin=3
MM3 net015 B3 net21 VSS nmos_rvt w=81.0n l=20n nfin=3
MM4 net21 A2 VSS VSS nmos_rvt w=81.0n l=20n nfin=3
MM2 net015 B2 net21 VSS nmos_rvt w=81.0n l=20n nfin=3
MM1 net21 A1 VSS VSS nmos_rvt w=81.0n l=20n nfin=3
MM0 net015 B1 net21 VSS nmos_rvt w=81.0n l=20n nfin=3
MM14 Y net015 VDD VDD pmos_rvt w=162.00n l=20n nfin=6
MM13 net34 B1 VDD VDD pmos_rvt w=81.0n l=20n nfin=3
MM11 net33 B2 net34 VDD pmos_rvt w=81.0n l=20n nfin=3
MM8 net015 B3 net33 VDD pmos_rvt w=81.0n l=20n nfin=3
MM12 net35 A1 VDD VDD pmos_rvt w=81.0n l=20n nfin=3
MM9 net36 A2 net35 VDD pmos_rvt w=81.0n l=20n nfin=3
MM6 net015 A3 net36 VDD pmos_rvt w=81.0n l=20n nfin=3
.ENDS

.SUBCKT OAI211xp5_ASAP7_75t_R A1 A2 B C VDD VSS Y
MM39 Y C VDD VDD pmos_rvt w=54.0n l=20n nfin=2
MM38 Y B VDD VDD pmos_rvt w=54.0n l=20n nfin=2
MM37 Y A2 net20 VDD pmos_rvt w=54.0n l=20n nfin=2
MM36 net20 A1 VDD VDD pmos_rvt w=54.0n l=20n nfin=2
MM41 Y A2 net10 VSS nmos_rvt w=81.0n l=20n nfin=3
MM43 net19 C VSS VSS nmos_rvt w=81.0n l=20n nfin=3
MM40 Y A1 net10 VSS nmos_rvt w=81.0n l=20n nfin=3
MM42 net10 B net19 VSS nmos_rvt w=81.0n l=20n nfin=3
.ENDS

.SUBCKT OAI21x1_ASAP7_75t_R A1 A2 B VDD VSS Y
M0 noxref_6 B Y VSS nmos_rvt L=2e-08 W=8.1e-08 nfin=3
M1 VSS A1 noxref_6 VSS nmos_rvt L=2e-08 W=8.1e-08 nfin=3
M2 noxref_6 A2 VSS VSS nmos_rvt L=2e-08 W=8.1e-08 nfin=3
M3 noxref_6 A2 VSS VSS nmos_rvt L=2e-08 W=8.1e-08 nfin=3
M4 VSS A1 noxref_6 VSS nmos_rvt L=2e-08 W=8.1e-08 nfin=3
M5 noxref_6 B Y VSS nmos_rvt L=2e-08 W=8.1e-08 nfin=3
M6 Y B VDD VDD pmos_rvt L=2e-08 W=8.1e-08 nfin=3
M7 Y A1 noxref_8 VDD pmos_rvt L=2e-08 W=8.1e-08 nfin=3
M8 noxref_8 A2 VDD VDD pmos_rvt L=2e-08 W=8.1e-08 nfin=3
M9 noxref_9 A2 VDD VDD pmos_rvt L=2e-08 W=8.1e-08 nfin=3
M10 Y A1 noxref_9 VDD pmos_rvt L=2e-08 W=8.1e-08 nfin=3
M11 Y B VDD VDD pmos_rvt L=2e-08 W=8.1e-08 nfin=3
.ENDS

.SUBCKT OAI21xp33_ASAP7_75t_R A1 A2 B VDD VSS Y
MM2 Y B VDD VDD pmos_rvt w=54.0n l=20n nfin=2
MM1 Y A2 net27 VDD pmos_rvt w=54.0n l=20n nfin=2
MM0 net27 A1 VDD VDD pmos_rvt w=54.0n l=20n nfin=2
MM6 net11 B VSS VSS nmos_rvt w=54.0n l=20n nfin=2
MM5 Y A2 net11 VSS nmos_rvt w=54.0n l=20n nfin=2
MM4 Y A1 net11 VSS nmos_rvt w=54.0n l=20n nfin=2
.ENDS

.SUBCKT OAI21xp5_ASAP7_75t_R A1 A2 B VDD VSS Y
MM2 Y B VDD VDD pmos_rvt w=81.0n l=20n nfin=3
MM1 Y A2 net27 VDD pmos_rvt w=81.0n l=20n nfin=3
MM0 net27 A1 VDD VDD pmos_rvt w=81.0n l=20n nfin=3
MM6 net11 B VSS VSS nmos_rvt w=81.0n l=20n nfin=3
MM5 Y A2 net11 VSS nmos_rvt w=81.0n l=20n nfin=3
MM4 Y A1 net11 VSS nmos_rvt w=81.0n l=20n nfin=3
.ENDS

.SUBCKT OAI221xp5_ASAP7_75t_R A1 A2 B1 B2 C VDD VSS Y
MM11 net15 B2 net29 VSS nmos_rvt w=81.0n l=20n nfin=3
MM10 net29 A2 VSS VSS nmos_rvt w=81.0n l=20n nfin=3
MM9 net29 A1 VSS VSS nmos_rvt w=81.0n l=20n nfin=3
MM6 net15 B1 net29 VSS nmos_rvt w=81.0n l=20n nfin=3
MM12 Y C net15 VSS nmos_rvt w=81.0n l=20n nfin=3
MM4 Y C VDD VDD pmos_rvt w=54.0n l=20n nfin=2
MM3 Y B2 net32 VDD pmos_rvt w=54.0n l=20n nfin=2
MM2 net32 B1 VDD VDD pmos_rvt w=54.0n l=20n nfin=2
MM1 Y A2 net30 VDD pmos_rvt w=54.0n l=20n nfin=2
MM0 net30 A1 VDD VDD pmos_rvt w=54.0n l=20n nfin=2
.ENDS

.SUBCKT OAI222xp33_ASAP7_75t_R A1 A2 B1 B2 C1 C2 VDD VSS Y
MM7 net28 C2 VDD VDD pmos_rvt w=81.0n l=20n nfin=3
MM6 Y C1 net28 VDD pmos_rvt w=81.0n l=20n nfin=3
MM5 Y B1 net29 VDD pmos_rvt w=81.0n l=20n nfin=3
MM4 net29 B2 VDD VDD pmos_rvt w=81.0n l=20n nfin=3
MM3 Y A1 net30 VDD pmos_rvt w=81.0n l=20n nfin=3
MM2 net30 A2 VDD VDD pmos_rvt w=81.0n l=20n nfin=3
MM13 net010 C2 VSS VSS nmos_rvt w=81.0n l=20n nfin=3
MM12 net011 B2 net010 VSS nmos_rvt w=81.0n l=20n nfin=3
MM11 Y A2 net011 VSS nmos_rvt w=81.0n l=20n nfin=3
MM10 net010 C1 VSS VSS nmos_rvt w=81.0n l=20n nfin=3
MM9 net011 B1 net010 VSS nmos_rvt w=81.0n l=20n nfin=3
MM8 Y A1 net011 VSS nmos_rvt w=81.0n l=20n nfin=3
.ENDS

.SUBCKT OAI22x1_ASAP7_75t_R A1 A2 B1 B2 VDD VSS Y
M0 VSS B2 noxref_7 VSS nmos_rvt L=2e-08 W=8.1e-08 nfin=3
M1 noxref_7 B1 VSS VSS nmos_rvt L=2e-08 W=8.1e-08 nfin=3
M2 noxref_7 B1 VSS VSS nmos_rvt L=2e-08 W=8.1e-08 nfin=3
M3 VSS B2 noxref_7 VSS nmos_rvt L=2e-08 W=8.1e-08 nfin=3
M4 Y A2 noxref_7 VSS nmos_rvt L=2e-08 W=8.1e-08 nfin=3
M5 noxref_7 A1 Y VSS nmos_rvt L=2e-08 W=8.1e-08 nfin=3
M6 noxref_7 A1 Y VSS nmos_rvt L=2e-08 W=8.1e-08 nfin=3
M7 Y A2 noxref_7 VSS nmos_rvt L=2e-08 W=8.1e-08 nfin=3
M8 Y B2 noxref_9 VDD pmos_rvt L=2e-08 W=8.1e-08 nfin=3
M9 noxref_9 B1 VDD VDD pmos_rvt L=2e-08 W=8.1e-08 nfin=3
M10 noxref_10 B1 VDD VDD pmos_rvt L=2e-08 W=8.1e-08 nfin=3
M11 Y B2 noxref_10 VDD pmos_rvt L=2e-08 W=8.1e-08 nfin=3
M12 Y A2 noxref_11 VDD pmos_rvt L=2e-08 W=8.1e-08 nfin=3
M13 noxref_11 A1 VDD VDD pmos_rvt L=2e-08 W=8.1e-08 nfin=3
M14 noxref_12 A1 VDD VDD pmos_rvt L=2e-08 W=8.1e-08 nfin=3
M15 Y A2 noxref_12 VDD pmos_rvt L=2e-08 W=8.1e-08 nfin=3
.ENDS

.SUBCKT OAI22xp33_ASAP7_75t_R A1 A2 B1 B2 VDD VSS Y
MM3 net3 B2 VSS VSS nmos_rvt w=54.0n l=20n nfin=2
MM2 Y A2 net3 VSS nmos_rvt w=54.0n l=20n nfin=2
MM1 net3 B1 VSS VSS nmos_rvt w=54.0n l=20n nfin=2
MM0 Y A1 net3 VSS nmos_rvt w=54.0n l=20n nfin=2
MM8 net13 A1 VDD VDD pmos_rvt w=54.0n l=20n nfin=2
MM11 Y A2 net13 VDD pmos_rvt w=54.0n l=20n nfin=2
MM6 net14 B1 VDD VDD pmos_rvt w=54.0n l=20n nfin=2
MM10 Y B2 net14 VDD pmos_rvt w=54.0n l=20n nfin=2
.ENDS

.SUBCKT OAI22xp5_ASAP7_75t_R A1 A2 B1 B2 VDD VSS Y
MM3 net3 B2 VSS VSS nmos_rvt w=81.0n l=20n nfin=3
MM2 Y A2 net3 VSS nmos_rvt w=81.0n l=20n nfin=3
MM1 net3 B1 VSS VSS nmos_rvt w=81.0n l=20n nfin=3
MM0 Y A1 net3 VSS nmos_rvt w=81.0n l=20n nfin=3
MM8 net13 A1 VDD VDD pmos_rvt w=81.0n l=20n nfin=3
MM11 Y A2 net13 VDD pmos_rvt w=81.0n l=20n nfin=3
MM6 net14 B1 VDD VDD pmos_rvt w=81.0n l=20n nfin=3
MM10 Y B2 net14 VDD pmos_rvt w=81.0n l=20n nfin=3
.ENDS

.SUBCKT OAI311xp33_ASAP7_75t_R A1 A2 A3 B1 C1 VDD VSS Y
MM16 net037 A3 VDD VDD pmos_rvt w=81.0n l=20n nfin=3
MM7 Y C1 VDD VDD pmos_rvt w=54.0n l=20n nfin=2
MM5 Y B1 VDD VDD pmos_rvt w=54.0n l=20n nfin=2
MM3 Y A1 net30 VDD pmos_rvt w=81.0n l=20n nfin=3
MM2 net30 A2 net037 VDD pmos_rvt w=81.0n l=20n nfin=3
MM22 VSS A3 net011 VSS nmos_rvt w=81.0n l=20n nfin=3
MM11 VSS A1 net011 VSS nmos_rvt w=81.0n l=20n nfin=3
MM10 net022 C1 Y VSS nmos_rvt w=81.0n l=20n nfin=3
MM9 net011 B1 net022 VSS nmos_rvt w=81.0n l=20n nfin=3
MM8 VSS A2 net011 VSS nmos_rvt w=81.0n l=20n nfin=3
.ENDS

.SUBCKT OAI31xp33_ASAP7_75t_R A1 A2 A3 B VDD VSS Y
MM1 net039 A2 VSS VSS nmos_rvt w=54.0n l=20n nfin=2
MM11 Y B net039 VSS nmos_rvt w=54.0n l=20n nfin=2
MM0 net039 A1 VSS VSS nmos_rvt w=54.0n l=20n nfin=2
MM8 net039 A3 VSS VSS nmos_rvt w=54.0n l=20n nfin=2
MM15 Y B VDD VDD pmos_rvt w=54.0n l=20n nfin=2
MM14 net047 A1 VDD VDD pmos_rvt w=81.0n l=20n nfin=3
MM13 net048 A2 net047 VDD pmos_rvt w=81.0n l=20n nfin=3
MM12 Y A3 net048 VDD pmos_rvt w=81.0n l=20n nfin=3
.ENDS

.SUBCKT OAI31xp67_ASAP7_75t_R A1 A2 A3 B VDD VSS Y
MM1 net17 A2 VSS VSS nmos_rvt w=162.00n l=20n nfin=6
MM11 Y B net17 VSS nmos_rvt w=162.00n l=20n nfin=6
MM0 net17 A1 VSS VSS nmos_rvt w=162.00n l=20n nfin=6
MM8 net17 A3 VSS VSS nmos_rvt w=162.00n l=20n nfin=6
MM15 Y B VDD VDD pmos_rvt w=54.0n l=20n nfin=2
MM14 net22 A1 VDD VDD pmos_rvt w=162.00n l=20n nfin=6
MM13 net23 A2 net22 VDD pmos_rvt w=162.00n l=20n nfin=6
MM12 Y A3 net23 VDD pmos_rvt w=162.00n l=20n nfin=6
.ENDS

.SUBCKT OAI321xp33_ASAP7_75t_R A1 A2 A3 B1 B2 C VDD VSS Y
MM8 net013 B2 Y VSS nmos_rvt w=81.0n l=20n nfin=3
MM12 net012 C net013 VSS nmos_rvt w=81.0n l=20n nfin=3
MM9 net013 B1 Y VSS nmos_rvt w=81.0n l=20n nfin=3
MM10 VSS A3 net012 VSS nmos_rvt w=81.0n l=20n nfin=3
MM7 VSS A2 net012 VSS nmos_rvt w=81.0n l=20n nfin=3
MM6 VSS A1 net012 VSS nmos_rvt w=81.0n l=20n nfin=3
MM11 net031 B2 Y VDD pmos_rvt w=54.0n l=20n nfin=2
MM0 VDD C Y VDD pmos_rvt w=54.0n l=20n nfin=2
MM5 VDD B1 net031 VDD pmos_rvt w=54.0n l=20n nfin=2
MM4 VDD A3 net032 VDD pmos_rvt w=81.0n l=20n nfin=3
MM2 net29 A1 Y VDD pmos_rvt w=81.0n l=20n nfin=3
MM3 net032 A2 net29 VDD pmos_rvt w=81.0n l=20n nfin=3
.ENDS

.SUBCKT OAI322xp33_ASAP7_75t_R A1 A2 A3 B1 B2 C1 C2 VDD VSS Y
MM16 net037 A1 VDD VDD pmos_rvt w=81.0n l=20n nfin=3
MM7 net28 C2 VDD VDD pmos_rvt w=54.0n l=20n nfin=2
MM6 Y C1 net28 VDD pmos_rvt w=54.0n l=20n nfin=2
MM5 Y B1 net29 VDD pmos_rvt w=54.0n l=20n nfin=2
MM4 net29 B2 VDD VDD pmos_rvt w=54.0n l=20n nfin=2
MM3 Y A3 net30 VDD pmos_rvt w=81.0n l=20n nfin=3
MM2 net30 A2 net037 VDD pmos_rvt w=81.0n l=20n nfin=3
MM22 net026 A3 net022 VSS nmos_rvt w=81.0n l=20n nfin=3
MM13 net022 C1 Y VSS nmos_rvt w=81.0n l=20n nfin=3
MM12 net026 A2 net022 VSS nmos_rvt w=81.0n l=20n nfin=3
MM11 VSS B2 net026 VSS nmos_rvt w=81.0n l=20n nfin=3
MM10 net022 C2 Y VSS nmos_rvt w=81.0n l=20n nfin=3
MM9 net026 A1 net022 VSS nmos_rvt w=81.0n l=20n nfin=3
MM8 VSS B1 net026 VSS nmos_rvt w=81.0n l=20n nfin=3
.ENDS

.SUBCKT OAI32xp33_ASAP7_75t_R A1 A2 A3 B1 B2 VDD VSS Y
MM21 net019 A3 VSS VSS nmos_rvt w=54.0n l=20n nfin=2
MM1 Y B2 net019 VSS nmos_rvt w=54.0n l=20n nfin=2
MM5 Y B1 net019 VSS nmos_rvt w=54.0n l=20n nfin=2
MM15 net019 A2 VSS VSS nmos_rvt w=54.0n l=20n nfin=2
MM14 net019 A1 VSS VSS nmos_rvt w=54.0n l=20n nfin=2
MM0 net025 A3 VDD VDD pmos_rvt w=81.0n l=20n nfin=3
MM2 net24 A2 net025 VDD pmos_rvt w=81.0n l=20n nfin=3
MM3 Y A1 net24 VDD pmos_rvt w=81.0n l=20n nfin=3
MM18 Y B1 net027 VDD pmos_rvt w=54.0n l=20n nfin=2
MM13 net027 B2 VDD VDD pmos_rvt w=54.0n l=20n nfin=2
.ENDS

.SUBCKT OAI331xp33_ASAP7_75t_R A1 A2 A3 B1 B2 B3 C1 VDD VSS Y
MM4 net012 B3 net031 VSS nmos_rvt w=81.0n l=20n nfin=3
MM9 VSS A1 net012 VSS nmos_rvt w=81.0n l=20n nfin=3
MM8 VSS A2 net012 VSS nmos_rvt w=81.0n l=20n nfin=3
MM7 VSS A3 net012 VSS nmos_rvt w=81.0n l=20n nfin=3
MM6 net012 B1 net031 VSS nmos_rvt w=81.0n l=20n nfin=3
MM1 net031 C1 Y VSS nmos_rvt w=81.0n l=20n nfin=3
MM5 net012 B2 net031 VSS nmos_rvt w=81.0n l=20n nfin=3
MM17 VDD C1 Y VDD pmos_rvt w=81.0n l=20n nfin=3
MM12 net033 B1 Y VDD pmos_rvt w=81.0n l=20n nfin=3
MM11 net063 B2 net033 VDD pmos_rvt w=81.0n l=20n nfin=3
MM10 VDD B3 net063 VDD pmos_rvt w=81.0n l=20n nfin=3
MM3 VDD A3 net26 VDD pmos_rvt w=81.0n l=20n nfin=3
MM14 net037 A1 Y VDD pmos_rvt w=81.0n l=20n nfin=3
MM2 net26 A2 net037 VDD pmos_rvt w=81.0n l=20n nfin=3
.ENDS

.SUBCKT OAI332xp33_ASAP7_75t_R A1 A2 A3 B1 B2 B3 C1 C2 VDD VSS Y
MM9 VSS A1 net012 VSS nmos_rvt w=81.0n l=20n nfin=3
MM8 VSS A2 net012 VSS nmos_rvt w=81.0n l=20n nfin=3
MM7 VSS A3 net012 VSS nmos_rvt w=81.0n l=20n nfin=3
MM6 net012 B1 net031 VSS nmos_rvt w=81.0n l=20n nfin=3
MM1 net031 C1 Y VSS nmos_rvt w=81.0n l=20n nfin=3
MM5 net012 B2 net031 VSS nmos_rvt w=81.0n l=20n nfin=3
MM4 net012 B3 net031 VSS nmos_rvt w=81.0n l=20n nfin=3
MM0 net031 C2 Y VSS nmos_rvt w=81.0n l=20n nfin=3
MM17 net035 C1 Y VDD pmos_rvt w=81.0n l=20n nfin=3
MM16 VDD C2 net035 VDD pmos_rvt w=81.0n l=20n nfin=3
MM12 net033 B1 Y VDD pmos_rvt w=81.0n l=20n nfin=3
MM11 net063 B2 net033 VDD pmos_rvt w=81.0n l=20n nfin=3
MM10 VDD B3 net063 VDD pmos_rvt w=81.0n l=20n nfin=3
MM3 VDD A3 net26 VDD pmos_rvt w=81.0n l=20n nfin=3
MM14 net037 A1 Y VDD pmos_rvt w=81.0n l=20n nfin=3
MM2 net26 A2 net037 VDD pmos_rvt w=81.0n l=20n nfin=3
.ENDS

.SUBCKT OAI333xp33_ASAP7_75t_R A1 A2 A3 B1 B2 B3 C1 C2 C3 VDD VSS Y
MM13 VDD C3 net040 VDD pmos_rvt w=81.0n l=20n nfin=3
MM14 net084 A1 Y VDD pmos_rvt w=81.0n l=20n nfin=3
MM16 net040 C2 net086 VDD pmos_rvt w=81.0n l=20n nfin=3
MM12 net087 B1 Y VDD pmos_rvt w=81.0n l=20n nfin=3
MM11 net041 B2 net087 VDD pmos_rvt w=81.0n l=20n nfin=3
MM17 net086 C1 Y VDD pmos_rvt w=81.0n l=20n nfin=3
MM3 VDD A3 net038 VDD pmos_rvt w=81.0n l=20n nfin=3
MM10 VDD B3 net041 VDD pmos_rvt w=81.0n l=20n nfin=3
MM2 net038 A2 net084 VDD pmos_rvt w=81.0n l=20n nfin=3
MM4 net068 B3 net015 VSS nmos_rvt w=81.0n l=20n nfin=3
MM1 net015 A1 Y VSS nmos_rvt w=81.0n l=20n nfin=3
MM8 VSS C2 net068 VSS nmos_rvt w=81.0n l=20n nfin=3
MM9 VSS C1 net068 VSS nmos_rvt w=81.0n l=20n nfin=3
MM6 net068 B1 net015 VSS nmos_rvt w=81.0n l=20n nfin=3
MM7 VSS C3 net068 VSS nmos_rvt w=81.0n l=20n nfin=3
MM15 net015 A3 Y VSS nmos_rvt w=81.0n l=20n nfin=3
MM5 net068 B2 net015 VSS nmos_rvt w=81.0n l=20n nfin=3
MM0 net015 A2 Y VSS nmos_rvt w=81.0n l=20n nfin=3
.ENDS

.SUBCKT OAI33xp33_ASAP7_75t_R A1 A2 A3 B1 B2 B3 VDD VSS Y
MM33 Y B1 net028 VSS nmos_rvt w=54.0n l=20n nfin=2
MM35 net028 A3 VSS VSS nmos_rvt w=54.0n l=20n nfin=2
MM32 Y B2 net028 VSS nmos_rvt w=54.0n l=20n nfin=2
MM38 net028 A2 VSS VSS nmos_rvt w=54.0n l=20n nfin=2
MM31 Y B3 net028 VSS nmos_rvt w=54.0n l=20n nfin=2
MM37 net028 A1 VSS VSS nmos_rvt w=54.0n l=20n nfin=2
MM44 net052 B1 VDD VDD pmos_rvt w=81.0n l=20n nfin=3
MM45 net050 B2 net052 VDD pmos_rvt w=81.0n l=20n nfin=3
MM48 Y B3 net050 VDD pmos_rvt w=81.0n l=20n nfin=3
MM39 net018 A1 VDD VDD pmos_rvt w=81.0n l=20n nfin=3
MM46 net54 A2 net018 VDD pmos_rvt w=81.0n l=20n nfin=3
MM47 Y A3 net54 VDD pmos_rvt w=81.0n l=20n nfin=3
.ENDS

.SUBCKT OR2x2_ASAP7_75t_R A B VDD VSS Y
M0 N_M0_d B VSS VSS nmos_rvt L=2e-08 W=5.4e-08 nfin=2
M1 VSS A N_M0_d VSS nmos_rvt L=2e-08 W=5.4e-08 nfin=2
M2 Y N_M0_d VSS VSS nmos_rvt L=2e-08 W=8.1e-08 nfin=3
M3 Y N_M0_d VSS VSS nmos_rvt L=2e-08 W=8.1e-08 nfin=3
M4 N_M4_d B N_M0_d VDD pmos_rvt L=2e-08 W=8.1e-08 nfin=3
M5 VDD A N_M4_d VDD pmos_rvt L=2e-08 W=8.1e-08 nfin=3
M6 Y N_M0_d VDD VDD pmos_rvt L=2e-08 W=8.1e-08 nfin=3
M7 Y N_M0_d VDD VDD pmos_rvt L=2e-08 W=8.1e-08 nfin=3
.ENDS

.SUBCKT OR2x4_ASAP7_75t_R A B VDD VSS Y
M0 N_M0_d B VSS VSS nmos_rvt L=2e-08 W=5.4e-08 nfin=2
M1 VSS A N_M0_d VSS nmos_rvt L=2e-08 W=5.4e-08 nfin=2
M2 Y N_M0_d VSS VSS nmos_rvt L=2e-08 W=8.1e-08 nfin=3
M3 Y N_M0_d VSS VSS nmos_rvt L=2e-08 W=8.1e-08 nfin=3
M4 Y N_M0_d VSS VSS nmos_rvt L=2e-08 W=8.1e-08 nfin=3
M5 Y N_M0_d VSS VSS nmos_rvt L=2e-08 W=8.1e-08 nfin=3
M6 N_M6_d B N_M0_d VDD pmos_rvt L=2e-08 W=8.1e-08 nfin=3
M7 VDD A N_M6_d VDD pmos_rvt L=2e-08 W=8.1e-08 nfin=3
M8 Y N_M0_d VDD VDD pmos_rvt L=2e-08 W=8.1e-08 nfin=3
M9 Y N_M0_d VDD VDD pmos_rvt L=2e-08 W=8.1e-08 nfin=3
M10 Y N_M0_d VDD VDD pmos_rvt L=2e-08 W=8.1e-08 nfin=3
M11 Y N_M0_d VDD VDD pmos_rvt L=2e-08 W=8.1e-08 nfin=3
.ENDS

.SUBCKT OR2x6_ASAP7_75t_R A B VDD VSS Y
MM5 VSS net7 Y VSS nmos_rvt w=486.00n l=20n nfin=18
MM1 VSS B net7 VSS nmos_rvt w=108.00n l=20n nfin=4
MM2 VSS A net7 VSS nmos_rvt w=108.00n l=20n nfin=4
MM0 VDD net7 Y VDD pmos_rvt w=486.00n l=20n nfin=18
MM4 net15 B net7 VDD pmos_rvt w=162.00n l=20n nfin=6
MM3 VDD A net15 VDD pmos_rvt w=162.00n l=20n nfin=6
.ENDS

.SUBCKT OR3x1_ASAP7_75t_R A B C VDD VSS Y
M0 VSS A N_M0_s VSS nmos_rvt L=2e-08 W=8.1e-08 nfin=3
M1 N_M0_s B VSS VSS nmos_rvt L=2e-08 W=8.1e-08 nfin=3
M2 VSS C N_M0_s VSS nmos_rvt L=2e-08 W=8.1e-08 nfin=3
M3 Y N_M0_s VSS VSS nmos_rvt L=2e-08 W=8.1e-08 nfin=3
M4 N_M4_d A N_M0_s VDD pmos_rvt L=2e-08 W=8.1e-08 nfin=3
M5 N_M5_d B N_M4_d VDD pmos_rvt L=2e-08 W=8.1e-08 nfin=3
M6 VDD C N_M5_d VDD pmos_rvt L=2e-08 W=8.1e-08 nfin=3
M7 Y N_M0_s VDD VDD pmos_rvt L=2e-08 W=8.1e-08 nfin=3
.ENDS

.SUBCKT OR3x2_ASAP7_75t_R A B C VDD VSS Y
M0 VSS A N_M0_s VSS nmos_rvt L=2e-08 W=8.1e-08 nfin=3
M1 N_M0_s B VSS VSS nmos_rvt L=2e-08 W=8.1e-08 nfin=3
M2 VSS C N_M0_s VSS nmos_rvt L=2e-08 W=8.1e-08 nfin=3
M3 Y N_M0_s VSS VSS nmos_rvt L=2e-08 W=8.1e-08 nfin=3
M4 Y N_M0_s VSS VSS nmos_rvt L=2e-08 W=8.1e-08 nfin=3
M5 N_M5_d A N_M0_s VDD pmos_rvt L=2e-08 W=8.1e-08 nfin=3
M6 N_M6_d B N_M5_d VDD pmos_rvt L=2e-08 W=8.1e-08 nfin=3
M7 VDD C N_M6_d VDD pmos_rvt L=2e-08 W=8.1e-08 nfin=3
M8 Y N_M0_s VDD VDD pmos_rvt L=2e-08 W=8.1e-08 nfin=3
M9 Y N_M0_s VDD VDD pmos_rvt L=2e-08 W=8.1e-08 nfin=3
.ENDS

.SUBCKT OR3x4_ASAP7_75t_R A B C VDD VSS Y
M0 VSS A N_M0_s VSS nmos_rvt L=2e-08 W=8.1e-08 nfin=3
M1 N_M0_s B VSS VSS nmos_rvt L=2e-08 W=8.1e-08 nfin=3
M2 VSS C N_M0_s VSS nmos_rvt L=2e-08 W=8.1e-08 nfin=3
M3 Y N_M0_s VSS VSS nmos_rvt L=2e-08 W=8.1e-08 nfin=3
M4 Y N_M0_s VSS VSS nmos_rvt L=2e-08 W=8.1e-08 nfin=3
M5 Y N_M0_s VSS VSS nmos_rvt L=2e-08 W=8.1e-08 nfin=3
M6 Y N_M0_s VSS VSS nmos_rvt L=2e-08 W=8.1e-08 nfin=3
M7 N_M7_d A N_M0_s VDD pmos_rvt L=2e-08 W=8.1e-08 nfin=3
M8 N_M8_d B N_M7_d VDD pmos_rvt L=2e-08 W=8.1e-08 nfin=3
M9 VDD C N_M8_d VDD pmos_rvt L=2e-08 W=8.1e-08 nfin=3
M10 Y N_M0_s VDD VDD pmos_rvt L=2e-08 W=8.1e-08 nfin=3
M11 Y N_M0_s VDD VDD pmos_rvt L=2e-08 W=8.1e-08 nfin=3
M12 Y N_M0_s VDD VDD pmos_rvt L=2e-08 W=8.1e-08 nfin=3
M13 Y N_M0_s VDD VDD pmos_rvt L=2e-08 W=8.1e-08 nfin=3
.ENDS

.SUBCKT OR4x1_ASAP7_75t_R A B C D VDD VSS Y
M0 VSS N_M0_g Y VSS nmos_rvt L=2e-08 W=8.1e-08 nfin=3
M1 N_M0_g D VSS VSS nmos_rvt L=2e-08 W=8.1e-08 nfin=3
M2 VSS C N_M0_g VSS nmos_rvt L=2e-08 W=8.1e-08 nfin=3
M3 N_M0_g B VSS VSS nmos_rvt L=2e-08 W=8.1e-08 nfin=3
M4 VSS A N_M0_g VSS nmos_rvt L=2e-08 W=8.1e-08 nfin=3
M5 VDD N_M0_g Y VDD pmos_rvt L=2e-08 W=8.1e-08 nfin=3
M6 N_M6_d D VDD VDD pmos_rvt L=2e-08 W=8.1e-08 nfin=3
M7 N_M7_d C N_M6_d VDD pmos_rvt L=2e-08 W=8.1e-08 nfin=3
M8 N_M8_d B N_M7_d VDD pmos_rvt L=2e-08 W=8.1e-08 nfin=3
M9 N_M0_g A N_M8_d VDD pmos_rvt L=2e-08 W=8.1e-08 nfin=3
.ENDS

.SUBCKT OR4x2_ASAP7_75t_R A B C D VDD VSS Y
MM9 Y net12 VSS VSS nmos_rvt w=162.00n l=20n nfin=6
MM3 net12 D VSS VSS nmos_rvt w=81.0n l=20n nfin=3
MM2 net12 C VSS VSS nmos_rvt w=81.0n l=20n nfin=3
MM1 net12 B VSS VSS nmos_rvt w=81.0n l=20n nfin=3
MM0 net12 A VSS VSS nmos_rvt w=81.0n l=20n nfin=3
MM8 Y net12 VDD VDD pmos_rvt w=162.00n l=20n nfin=6
MM7 net12 A pd1 VDD pmos_rvt w=81.0n l=20n nfin=3
MM6 pd1 B pd2 VDD pmos_rvt w=81.0n l=20n nfin=3
MM5 pd2 C pd3 VDD pmos_rvt w=81.0n l=20n nfin=3
MM4 pd3 D VDD VDD pmos_rvt w=81.0n l=20n nfin=3
.ENDS

.SUBCKT OR5x1_ASAP7_75t_R A B C D E VDD VSS Y
M0 VSS A N_M0_s VSS nmos_rvt L=2e-08 W=5.4e-08 nfin=2
M1 N_M0_s B VSS VSS nmos_rvt L=2e-08 W=5.4e-08 nfin=2
M2 VSS C N_M0_s VSS nmos_rvt L=2e-08 W=5.4e-08 nfin=2
M3 N_M0_s D VSS VSS nmos_rvt L=2e-08 W=5.4e-08 nfin=2
M4 VSS E N_M0_s VSS nmos_rvt L=2e-08 W=5.4e-08 nfin=2
M5 Y N_M0_s VSS VSS nmos_rvt L=2e-08 W=8.1e-08 nfin=3
M6 N_M6_d A N_M0_s VDD pmos_rvt L=2e-08 W=8.1e-08 nfin=3
M7 N_M7_d B N_M6_d VDD pmos_rvt L=2e-08 W=8.1e-08 nfin=3
M8 N_M8_d C N_M7_d VDD pmos_rvt L=2e-08 W=8.1e-08 nfin=3
M9 N_M9_d D N_M8_d VDD pmos_rvt L=2e-08 W=8.1e-08 nfin=3
M10 VDD E N_M9_d VDD pmos_rvt L=2e-08 W=8.1e-08 nfin=3
M11 Y N_M0_s VDD VDD pmos_rvt L=2e-08 W=8.1e-08 nfin=3
.ENDS

.SUBCKT OR5x2_ASAP7_75t_R A B C D E VDD VSS Y
MM9 VSS E net024 VSS nmos_rvt w=54.0n l=20n nfin=2
MM8 VSS D net024 VSS nmos_rvt w=54.0n l=20n nfin=2
MM7 VSS C net024 VSS nmos_rvt w=54.0n l=20n nfin=2
MM2 VSS B net024 VSS nmos_rvt w=54.0n l=20n nfin=2
MM1 VSS net024 Y VSS nmos_rvt w=162.00n l=20n nfin=6
MM10 VSS A net024 VSS nmos_rvt w=54.0n l=20n nfin=2
MM11 VDD net024 Y VDD pmos_rvt w=162.00n l=20n nfin=6
MM6 VDD E net027 VDD pmos_rvt w=81.0n l=20n nfin=3
MM5 net027 D net29 VDD pmos_rvt w=81.0n l=20n nfin=3
MM4 net30 B net023 VDD pmos_rvt w=81.0n l=20n nfin=3
MM0 net023 A net024 VDD pmos_rvt w=81.0n l=20n nfin=3
MM3 net29 C net30 VDD pmos_rvt w=81.0n l=20n nfin=3
.ENDS

.SUBCKT SDFHx1_ASAP7_75t_R CLK D QN SE SI VDD VSS
MM28 net0166 SEn VSS VSS nmos_rvt w=81.0n l=20n nfin=3
MM0 net0167 SE VSS VSS nmos_rvt w=81.0n l=20n nfin=3
MM6 MS MH VSS VSS nmos_rvt w=27.0n l=20n nfin=1
MM29 net0118 D net0166 VSS nmos_rvt w=81.0n l=20n nfin=3
MM30 SEn SE VSS VSS nmos_rvt w=27.0n l=20n nfin=1
MM8 pd3 MS VSS VSS nmos_rvt w=27.0n l=20n nfin=1
MM9 MH clkb pd3 VSS nmos_rvt w=27.0n l=20n nfin=1
MM12 MS clkb SH VSS nmos_rvt w=27.0n l=20n nfin=1
MM14 SS SH VSS VSS nmos_rvt w=27.0n l=20n nfin=1
MM16 pd5 SS VSS VSS nmos_rvt w=27.0n l=20n nfin=1
MM17 SH clkn pd5 VSS nmos_rvt w=27.0n l=20n nfin=1
MM20 clkn CLK VSS VSS nmos_rvt w=54.0n l=20n nfin=2
MM23 clkb clkn VSS VSS nmos_rvt w=54.0n l=20n nfin=2
MM24 QN SH VSS VSS nmos_rvt w=81.0n l=20n nfin=3
MM4 MH clkn net0118 VSS nmos_rvt w=81.0n l=20n nfin=3
MM5 net0118 SI net0167 VSS nmos_rvt w=81.0n l=20n nfin=3
MM27 net0120 SI net0141 VDD pmos_rvt w=81.0n l=20n nfin=3
MM21 clkn CLK VDD VDD pmos_rvt w=54.0n l=20n nfin=2
MM22 clkb clkn VDD VDD pmos_rvt w=54.0n l=20n nfin=2
MM3 net0120 SE net0141 VDD pmos_rvt w=81.0n l=20n nfin=3
MM1 MH clkb net0120 VDD pmos_rvt w=81.0n l=20n nfin=3
MM31 SEn SE VDD VDD pmos_rvt w=27n l=20n nfin=1
MM10 MH clkn pd2 VDD pmos_rvt w=27n l=20n nfin=1
MM2 net0141 SEn VDD VDD pmos_rvt w=81.0n l=20n nfin=3
MM11 pd2 MS VDD VDD pmos_rvt w=27n l=20n nfin=1
MM13 MS clkn SH VDD pmos_rvt w=27n l=20n nfin=1
MM7 MS MH VDD VDD pmos_rvt w=27n l=20n nfin=1
MM15 SS SH VDD VDD pmos_rvt w=27n l=20n nfin=1
MM18 SH clkb pd4 VDD pmos_rvt w=27n l=20n nfin=1
MM19 pd4 SS VDD VDD pmos_rvt w=27n l=20n nfin=1
MM25 QN SH VDD VDD pmos_rvt w=81.0n l=20n nfin=3
MM26 net0141 D VDD VDD pmos_rvt w=81.0n l=20n nfin=3
.ENDS

.SUBCKT SDFHx2_ASAP7_75t_R CLK D QN SE SI VDD VSS
MM5 net0118 SI net0166 VSS nmos_rvt w=81.0n l=20n nfin=3
MM4 MH clkn net0118 VSS nmos_rvt w=81.0n l=20n nfin=3
MM24 QN SH VSS VSS nmos_rvt w=162.00n l=20n nfin=6
MM23 clkb clkn VSS VSS nmos_rvt w=54.0n l=20n nfin=2
MM20 clkn CLK VSS VSS nmos_rvt w=54.0n l=20n nfin=2
MM17 SH clkn pd5 VSS nmos_rvt w=27.0n l=20n nfin=1
MM16 pd5 SS VSS VSS nmos_rvt w=27.0n l=20n nfin=1
MM14 SS SH VSS VSS nmos_rvt w=27.0n l=20n nfin=1
MM12 MS clkb SH VSS nmos_rvt w=27.0n l=20n nfin=1
MM9 MH clkb pd3 VSS nmos_rvt w=27.0n l=20n nfin=1
MM8 pd3 MS VSS VSS nmos_rvt w=27.0n l=20n nfin=1
MM30 SEn SE VSS VSS nmos_rvt w=27.0n l=20n nfin=1
MM29 net0118 D net0167 VSS nmos_rvt w=81.0n l=20n nfin=3
MM6 MS MH VSS VSS nmos_rvt w=27.0n l=20n nfin=1
MM0 net0166 SE VSS VSS nmos_rvt w=81.0n l=20n nfin=3
MM28 net0167 SEn VSS VSS nmos_rvt w=81.0n l=20n nfin=3
MM19 pd4 SS VDD VDD pmos_rvt w=27n l=20n nfin=1
MM18 SH clkb pd4 VDD pmos_rvt w=27n l=20n nfin=1
MM26 net0141 D VDD VDD pmos_rvt w=81.0n l=20n nfin=3
MM25 QN SH VDD VDD pmos_rvt w=162.00n l=20n nfin=6
MM22 clkb clkn VDD VDD pmos_rvt w=54.0n l=20n nfin=2
MM21 clkn CLK VDD VDD pmos_rvt w=54.0n l=20n nfin=2
MM15 SS SH VDD VDD pmos_rvt w=27n l=20n nfin=1
MM13 MS clkn SH VDD pmos_rvt w=27n l=20n nfin=1
MM11 pd2 MS VDD VDD pmos_rvt w=27n l=20n nfin=1
MM10 MH clkn pd2 VDD pmos_rvt w=27n l=20n nfin=1
MM7 MS MH VDD VDD pmos_rvt w=27n l=20n nfin=1
MM2 net0141 SEn VDD VDD pmos_rvt w=81.0n l=20n nfin=3
MM31 SEn SE VDD VDD pmos_rvt w=27n l=20n nfin=1
MM1 MH clkb net0120 VDD pmos_rvt w=81.0n l=20n nfin=3
MM3 net0120 SE net0141 VDD pmos_rvt w=81.0n l=20n nfin=3
MM27 net0120 SI net0141 VDD pmos_rvt w=81.0n l=20n nfin=3
.ENDS

.SUBCKT SDFHx3_ASAP7_75t_R CLK D QN SE SI VDD VSS
MM5 net13 SI net134 VSS nmos_rvt w=81.0n l=20n nfin=3
MM4 MH clkn net13 VSS nmos_rvt w=81.0n l=20n nfin=3
MM24 QN SH VSS VSS nmos_rvt w=243.00n l=20n nfin=9
MM23 clkb clkn VSS VSS nmos_rvt w=54.0n l=20n nfin=2
MM20 clkn CLK VSS VSS nmos_rvt w=54.0n l=20n nfin=2
MM17 SH clkn pd5 VSS nmos_rvt w=27.0n l=20n nfin=1
MM16 pd5 SS VSS VSS nmos_rvt w=27.0n l=20n nfin=1
MM14 SS SH VSS VSS nmos_rvt w=27.0n l=20n nfin=1
MM12 MS clkb SH VSS nmos_rvt w=27.0n l=20n nfin=1
MM9 MH clkb pd3 VSS nmos_rvt w=27.0n l=20n nfin=1
MM8 pd3 MS VSS VSS nmos_rvt w=27.0n l=20n nfin=1
MM30 SEn SE VSS VSS nmos_rvt w=27.0n l=20n nfin=1
MM29 net13 D net137 VSS nmos_rvt w=81.0n l=20n nfin=3
MM6 MS MH VSS VSS nmos_rvt w=27.0n l=20n nfin=1
MM0 net134 SE VSS VSS nmos_rvt w=81.0n l=20n nfin=3
MM28 net137 SEn VSS VSS nmos_rvt w=81.0n l=20n nfin=3
MM7 MS MH VDD VDD pmos_rvt w=27n l=20n nfin=1
MM2 net62 SEn VDD VDD pmos_rvt w=81.0n l=20n nfin=3
MM31 SEn SE VDD VDD pmos_rvt w=27n l=20n nfin=1
MM1 MH clkb net15 VDD pmos_rvt w=81.0n l=20n nfin=3
MM3 net15 SE net62 VDD pmos_rvt w=81.0n l=20n nfin=3
MM27 net15 SI net62 VDD pmos_rvt w=81.0n l=20n nfin=3
MM26 net62 D VDD VDD pmos_rvt w=81.0n l=20n nfin=3
MM25 QN SH VDD VDD pmos_rvt w=243.00n l=20n nfin=9
MM22 clkb clkn VDD VDD pmos_rvt w=54.0n l=20n nfin=2
MM21 clkn CLK VDD VDD pmos_rvt w=54.0n l=20n nfin=2
MM19 pd4 SS VDD VDD pmos_rvt w=27n l=20n nfin=1
MM18 SH clkb pd4 VDD pmos_rvt w=27n l=20n nfin=1
MM15 SS SH VDD VDD pmos_rvt w=27n l=20n nfin=1
MM13 MS clkn SH VDD pmos_rvt w=27n l=20n nfin=1
MM11 pd2 MS VDD VDD pmos_rvt w=27n l=20n nfin=1
MM10 MH clkn pd2 VDD pmos_rvt w=27n l=20n nfin=1
.ENDS

.SUBCKT SDFHx4_ASAP7_75t_R CLK D QN SE SI VDD VSS
MM30 SEn SE VSS VSS nmos_rvt w=81.0n l=20n nfin=3
MM29 pd1 D net066 VSS nmos_rvt w=81.0n l=20n nfin=3
MM28 net066 SEn VSS VSS nmos_rvt w=81.0n l=20n nfin=3
MM27 net067 SE VSS VSS nmos_rvt w=81.0n l=20n nfin=3
MM4 MH clkn pd1 VSS nmos_rvt w=81.0n l=20n nfin=3
MM5 pd1 SI net067 VSS nmos_rvt w=81.0n l=20n nfin=3
MM6 MS MH VSS VSS nmos_rvt w=81.0n l=20n nfin=3
MM8 pd3 MS VSS VSS nmos_rvt w=81.0n l=20n nfin=3
MM9 MH clkb pd3 VSS nmos_rvt w=81.0n l=20n nfin=3
MM12 MS clkb SH VSS nmos_rvt w=81.0n l=20n nfin=3
MM14 SS SH VSS VSS nmos_rvt w=81.0n l=20n nfin=3
MM16 pd5 SS VSS VSS nmos_rvt w=81.0n l=20n nfin=3
MM17 SH clkn pd5 VSS nmos_rvt w=81.0n l=20n nfin=3
MM20 clkn CLK VSS VSS nmos_rvt w=81.0n l=20n nfin=3
MM23 clkb clkn VSS VSS nmos_rvt w=81.0n l=20n nfin=3
MM24 QN SH VSS VSS nmos_rvt w=324.00n l=20n nfin=12
MM31 SEn SE VDD VDD pmos_rvt w=81.0n l=20n nfin=3
MM26 net54 D VDD VDD pmos_rvt w=81.0n l=20n nfin=3
MM2 pu1 SI net54 VDD pmos_rvt w=81.0n l=20n nfin=3
MM0 net54 SEn VDD VDD pmos_rvt w=81.0n l=20n nfin=3
MM3 pu1 SE net54 VDD pmos_rvt w=81.0n l=20n nfin=3
MM1 MH clkb pu1 VDD pmos_rvt w=81.0n l=20n nfin=3
MM7 MS MH VDD VDD pmos_rvt w=81.0n l=20n nfin=3
MM10 MH clkn pd2 VDD pmos_rvt w=81.0n l=20n nfin=3
MM11 pd2 MS VDD VDD pmos_rvt w=81.0n l=20n nfin=3
MM13 MS clkn SH VDD pmos_rvt w=81.0n l=20n nfin=3
MM15 SS SH VDD VDD pmos_rvt w=81.0n l=20n nfin=3
MM18 SH clkb pd4 VDD pmos_rvt w=81.0n l=20n nfin=3
MM19 pd4 SS VDD VDD pmos_rvt w=81.0n l=20n nfin=3
MM21 clkn CLK VDD VDD pmos_rvt w=81.0n l=20n nfin=3
MM22 clkb clkn VDD VDD pmos_rvt w=81.0n l=20n nfin=3
MM25 QN SH VDD VDD pmos_rvt w=324.00n l=20n nfin=12
.ENDS

.SUBCKT SDFLx1_ASAP7_75t_R CLK D QN SE SI VDD VSS
MM24 QN SH VSS VSS nmos_rvt w=81.0n l=20n nfin=3
MM23 clkb clkn VSS VSS nmos_rvt w=54.0n l=20n nfin=2
MM20 clkn CLK VSS VSS nmos_rvt w=54.0n l=20n nfin=2
MM17 SH clkb pd5 VSS nmos_rvt w=27.0n l=20n nfin=1
MM16 pd5 SS VSS VSS nmos_rvt w=27.0n l=20n nfin=1
MM14 SS SH VSS VSS nmos_rvt w=27.0n l=20n nfin=1
MM12 MS clkn SH VSS nmos_rvt w=27.0n l=20n nfin=1
MM9 MH clkn pd3 VSS nmos_rvt w=27.0n l=20n nfin=1
MM8 pd3 MS VSS VSS nmos_rvt w=27.0n l=20n nfin=1
MM6 MS MH VSS VSS nmos_rvt w=27.0n l=20n nfin=1
MM5 pd1 SE net0168 VSS nmos_rvt w=81.0n l=20n nfin=3
MM4 MH clkb pd1 VSS nmos_rvt w=81.0n l=20n nfin=3
MM0 SEn SE VSS VSS nmos_rvt w=81.0n l=20n nfin=3
MM26 net0168 SI VSS VSS nmos_rvt w=81.0n l=20n nfin=3
MM32 pd1 D net0167 VSS nmos_rvt w=81.0n l=20n nfin=3
MM29 net0167 SEn VSS VSS nmos_rvt w=81.0n l=20n nfin=3
MM13 MS clkb SH VDD pmos_rvt w=27n l=20n nfin=1
MM11 pd2 MS VDD VDD pmos_rvt w=27n l=20n nfin=1
MM1 MH clkn pu1 VDD pmos_rvt w=81.0n l=20n nfin=3
MM3 pu1 SI net0144 VDD pmos_rvt w=81.0n l=20n nfin=3
MM31 pu1 SE net0144 VDD pmos_rvt w=81.0n l=20n nfin=3
MM10 MH clkb pd2 VDD pmos_rvt w=27n l=20n nfin=1
MM2 SEn SE VDD VDD pmos_rvt w=81.0n l=20n nfin=3
MM27 net0144 SEn VDD VDD pmos_rvt w=81.0n l=20n nfin=3
MM30 net0144 D VDD VDD pmos_rvt w=81.0n l=20n nfin=3
MM7 MS MH VDD VDD pmos_rvt w=27n l=20n nfin=1
MM25 QN SH VDD VDD pmos_rvt w=81.0n l=20n nfin=3
MM22 clkb clkn VDD VDD pmos_rvt w=54.0n l=20n nfin=2
MM21 clkn CLK VDD VDD pmos_rvt w=54.0n l=20n nfin=2
MM19 pd4 SS VDD VDD pmos_rvt w=27n l=20n nfin=1
MM18 SH clkn pd4 VDD pmos_rvt w=27n l=20n nfin=1
MM15 SS SH VDD VDD pmos_rvt w=27n l=20n nfin=1
.ENDS

.SUBCKT SDFLx2_ASAP7_75t_R CLK D QN SE SI VDD VSS
MM29 net0168 SEn VSS VSS nmos_rvt w=81.0n l=20n nfin=3
MM32 pd1 D net0168 VSS nmos_rvt w=81.0n l=20n nfin=3
MM26 net0167 SI VSS VSS nmos_rvt w=81.0n l=20n nfin=3
MM0 SEn SE VSS VSS nmos_rvt w=81.0n l=20n nfin=3
MM4 MH clkb pd1 VSS nmos_rvt w=81.0n l=20n nfin=3
MM5 pd1 SE net0167 VSS nmos_rvt w=81.0n l=20n nfin=3
MM6 MS MH VSS VSS nmos_rvt w=27.0n l=20n nfin=1
MM8 pd3 MS VSS VSS nmos_rvt w=27.0n l=20n nfin=1
MM9 MH clkn pd3 VSS nmos_rvt w=27.0n l=20n nfin=1
MM12 MS clkn SH VSS nmos_rvt w=27.0n l=20n nfin=1
MM14 SS SH VSS VSS nmos_rvt w=27.0n l=20n nfin=1
MM16 pd5 SS VSS VSS nmos_rvt w=27.0n l=20n nfin=1
MM17 SH clkb pd5 VSS nmos_rvt w=27.0n l=20n nfin=1
MM20 clkn CLK VSS VSS nmos_rvt w=54.0n l=20n nfin=2
MM23 clkb clkn VSS VSS nmos_rvt w=54.0n l=20n nfin=2
MM24 QN SH VSS VSS nmos_rvt w=162.00n l=20n nfin=6
MM7 MS MH VDD VDD pmos_rvt w=27n l=20n nfin=1
MM10 MH clkb pd2 VDD pmos_rvt w=27n l=20n nfin=1
MM15 SS SH VDD VDD pmos_rvt w=27n l=20n nfin=1
MM18 SH clkn pd4 VDD pmos_rvt w=27n l=20n nfin=1
MM19 pd4 SS VDD VDD pmos_rvt w=27n l=20n nfin=1
MM11 pd2 MS VDD VDD pmos_rvt w=27n l=20n nfin=1
MM21 clkn CLK VDD VDD pmos_rvt w=54.0n l=20n nfin=2
MM22 clkb clkn VDD VDD pmos_rvt w=54.0n l=20n nfin=2
MM25 QN SH VDD VDD pmos_rvt w=162.00n l=20n nfin=6
MM13 MS clkb SH VDD pmos_rvt w=27n l=20n nfin=1
MM30 net0144 D VDD VDD pmos_rvt w=81.0n l=20n nfin=3
MM27 net0144 SEn VDD VDD pmos_rvt w=81.0n l=20n nfin=3
MM2 SEn SE VDD VDD pmos_rvt w=81.0n l=20n nfin=3
MM31 pu1 SE net0144 VDD pmos_rvt w=81.0n l=20n nfin=3
MM3 pu1 SI net0144 VDD pmos_rvt w=81.0n l=20n nfin=3
MM1 MH clkn pu1 VDD pmos_rvt w=81.0n l=20n nfin=3
.ENDS

.SUBCKT SDFLx3_ASAP7_75t_R CLK D QN SE SI VDD VSS
MM29 net061 SEn VSS VSS nmos_rvt w=81.0n l=20n nfin=3
MM32 pd1 D net061 VSS nmos_rvt w=81.0n l=20n nfin=3
MM26 net062 SI VSS VSS nmos_rvt w=81.0n l=20n nfin=3
MM0 SEn SE VSS VSS nmos_rvt w=81.0n l=20n nfin=3
MM4 MH clkb pd1 VSS nmos_rvt w=81.0n l=20n nfin=3
MM5 pd1 SE net062 VSS nmos_rvt w=81.0n l=20n nfin=3
MM6 MS MH VSS VSS nmos_rvt w=27.0n l=20n nfin=1
MM8 pd3 MS VSS VSS nmos_rvt w=27.0n l=20n nfin=1
MM9 MH clkn pd3 VSS nmos_rvt w=27.0n l=20n nfin=1
MM12 MS clkn SH VSS nmos_rvt w=27.0n l=20n nfin=1
MM14 SS SH VSS VSS nmos_rvt w=27.0n l=20n nfin=1
MM16 pd5 SS VSS VSS nmos_rvt w=27.0n l=20n nfin=1
MM17 SH clkb pd5 VSS nmos_rvt w=27.0n l=20n nfin=1
MM20 clkn CLK VSS VSS nmos_rvt w=54.0n l=20n nfin=2
MM23 clkb clkn VSS VSS nmos_rvt w=54.0n l=20n nfin=2
MM24 QN SH VSS VSS nmos_rvt w=243.00n l=20n nfin=9
MM30 net063 D VDD VDD pmos_rvt w=81.0n l=20n nfin=3
MM27 net063 SEn VDD VDD pmos_rvt w=81.0n l=20n nfin=3
MM2 SEn SE VDD VDD pmos_rvt w=81.0n l=20n nfin=3
MM31 pu1 SE net063 VDD pmos_rvt w=81.0n l=20n nfin=3
MM3 pu1 SI net063 VDD pmos_rvt w=81.0n l=20n nfin=3
MM1 MH clkn pu1 VDD pmos_rvt w=81.0n l=20n nfin=3
MM7 MS MH VDD VDD pmos_rvt w=27n l=20n nfin=1
MM10 MH clkb pd2 VDD pmos_rvt w=27n l=20n nfin=1
MM11 pd2 MS VDD VDD pmos_rvt w=27n l=20n nfin=1
MM13 MS clkb SH VDD pmos_rvt w=27n l=20n nfin=1
MM15 SS SH VDD VDD pmos_rvt w=27n l=20n nfin=1
MM18 SH clkn pd4 VDD pmos_rvt w=27n l=20n nfin=1
MM19 pd4 SS VDD VDD pmos_rvt w=27n l=20n nfin=1
MM21 clkn CLK VDD VDD pmos_rvt w=54.0n l=20n nfin=2
MM22 clkb clkn VDD VDD pmos_rvt w=54.0n l=20n nfin=2
MM25 QN SH VDD VDD pmos_rvt w=243.00n l=20n nfin=9
.ENDS

.SUBCKT SDFLx4_ASAP7_75t_R CLK D QN SE SI VDD VSS
MM30 SEn SE VSS VSS nmos_rvt w=81.0n l=20n nfin=3
MM29 pd1 D net066 VSS nmos_rvt w=81.0n l=20n nfin=3
MM28 net066 SEn VSS VSS nmos_rvt w=81.0n l=20n nfin=3
MM27 net067 SE VSS VSS nmos_rvt w=81.0n l=20n nfin=3
MM4 MH clkb pd1 VSS nmos_rvt w=81.0n l=20n nfin=3
MM5 pd1 SI net067 VSS nmos_rvt w=81.0n l=20n nfin=3
MM6 MS MH VSS VSS nmos_rvt w=81.0n l=20n nfin=3
MM8 pd3 MS VSS VSS nmos_rvt w=81.0n l=20n nfin=3
MM9 MH clkn pd3 VSS nmos_rvt w=81.0n l=20n nfin=3
MM12 MS clkn SH VSS nmos_rvt w=81.0n l=20n nfin=3
MM14 SS SH VSS VSS nmos_rvt w=81.0n l=20n nfin=3
MM16 pd5 SS VSS VSS nmos_rvt w=81.0n l=20n nfin=3
MM17 SH clkb pd5 VSS nmos_rvt w=81.0n l=20n nfin=3
MM20 clkn CLK VSS VSS nmos_rvt w=81.0n l=20n nfin=3
MM23 clkb clkn VSS VSS nmos_rvt w=81.0n l=20n nfin=3
MM24 QN SH VSS VSS nmos_rvt w=324.00n l=20n nfin=12
MM31 SEn SE VDD VDD pmos_rvt w=81.0n l=20n nfin=3
MM26 net54 D VDD VDD pmos_rvt w=81.0n l=20n nfin=3
MM2 pu1 SI net54 VDD pmos_rvt w=81.0n l=20n nfin=3
MM0 net54 SEn VDD VDD pmos_rvt w=81.0n l=20n nfin=3
MM3 pu1 SE net54 VDD pmos_rvt w=81.0n l=20n nfin=3
MM1 MH clkn pu1 VDD pmos_rvt w=81.0n l=20n nfin=3
MM7 MS MH VDD VDD pmos_rvt w=81.0n l=20n nfin=3
MM10 MH clkb pd2 VDD pmos_rvt w=81.0n l=20n nfin=3
MM11 pd2 MS VDD VDD pmos_rvt w=81.0n l=20n nfin=3
MM13 MS clkb SH VDD pmos_rvt w=81.0n l=20n nfin=3
MM15 SS SH VDD VDD pmos_rvt w=81.0n l=20n nfin=3
MM18 SH clkn pd4 VDD pmos_rvt w=81.0n l=20n nfin=3
MM19 pd4 SS VDD VDD pmos_rvt w=81.0n l=20n nfin=3
MM21 clkn CLK VDD VDD pmos_rvt w=81.0n l=20n nfin=3
MM22 clkb clkn VDD VDD pmos_rvt w=81.0n l=20n nfin=3
MM25 QN SH VDD VDD pmos_rvt w=324.00n l=20n nfin=12
.ENDS

* --------------------------------------------------------------------------
* TBUFx1_ASAP7_75t_R below is a port of TBUF_X1 from the Nangate Open
* Cell Library. Its licence requires the notice and statement reproduced here.
*
* Copyright (C) 2004-2010, Nangate Inc.  All rights reserved.
*
* Nangate Open Cell Library License, Version 1.0. February 20, 2008
*
* Permission is hereby granted, free of charge, to any person or
* organization obtaining a copy of the Open Cell Library and accompanying
* documentation (the "Library") covered by this license to use, reproduce,
* display, distribute, execute, and transmit the Library, and to prepare
* derivative works of the Library, and to permit third-parties to whom the
* Library is furnished to do so, all subject to the following:
*
* The copyright notices in the Library and this entire statement, including
* the above license grant, this restriction and the following disclaimer,
* must be included in all copies of the Library, in whole or in part, and
* all derivative works of the Library, unless such copies or derivative
* works are solely in the form of machine-executable object code generated
* by a source language processor. The library has been generated using a
* non-optimized open PDK and is not suited for any commercial purpose.
* Measuring or benchmarking the Library against any other library or
* standard cell set is prohibited. Any meaningful library benchmarking must
* be done in collaboration with Nangate or other providers of optimized and
* production-ready PDKs.
*
* THE LIBRARY IS PROVIDED "AS IS", WITHOUT WARRANTY OF ANY KIND, EXPRESS OR
* IMPLIED, INCLUDING BUT NOT LIMITED TO THE WARRANTIES OF MERCHANTABILITY,
* FITNESS FOR A PARTICULAR PURPOSE, TITLE AND NON-INFRINGEMENT. IN NO EVENT
* SHALL THE COPYRIGHT HOLDERS OR ANYONE DISTRIBUTING THE LIBRARY BE LIABLE
* FOR ANY DAMAGES OR OTHER LIABILITY, WHETHER IN CONTRACT, TORT OR
* OTHERWISE, ARISING FROM, OUT OF OR IN CONNECTION WITH THE LIBRARY OR THE
* USE OR OTHER DEALINGS IN THE LIBRARY.
* --------------------------------------------------------------------------
.SUBCKT TBUFx1_ASAP7_75t_R A EN VDD VSS Z
*.PININFO A:I EN:I VDD:P VSS:G Z:O
*.EQN Z=A
M0 VSS 1 Z VSS nmos_rvt w=81.0n l=20n nfin=3
M1 5 A 2 VSS nmos_rvt w=54.0n l=20n nfin=2
M2 VSS 3 5 VSS nmos_rvt w=54.0n l=20n nfin=2
M3 VSS A 1 VSS nmos_rvt w=54.0n l=20n nfin=2
M4 VSS EN 1 VSS nmos_rvt w=54.0n l=20n nfin=2
M5 VSS EN 3 VSS nmos_rvt w=54.0n l=20n nfin=2
M6 VDD 2 Z VDD pmos_rvt w=81.0n l=20n nfin=3
M7 VDD A 2 VDD pmos_rvt w=54.0n l=20n nfin=2
M8 2 3 VDD VDD pmos_rvt w=54.0n l=20n nfin=2
M9 VDD A 4 VDD pmos_rvt w=54.0n l=20n nfin=2
M10 4 EN 1 VDD pmos_rvt w=54.0n l=20n nfin=2
M11 VDD EN 3 VDD pmos_rvt w=54.0n l=20n nfin=2
.ENDS

.SUBCKT TIEHIx1_ASAP7_75t_R H VDD VSS
MM1 H net7 VDD VDD pmos_rvt w=54.0n l=20n nfin=2
MM2 net7 H VSS VSS nmos_rvt w=27.0n l=20n nfin=1
.ENDS

.SUBCKT TIELOx1_ASAP7_75t_R L VDD VSS
MM1 net9 L VDD VDD pmos_rvt w=27.0n l=20n nfin=1
MM2 L net9 VSS VSS nmos_rvt w=54.0n l=20n nfin=2
.ENDS

.SUBCKT XNOR2x1_ASAP7_75t_R A B VDD VSS Y
MM4 net015 A VSS VSS nmos_rvt w=162.00n l=20n nfin=6
MM5 net015 B VSS VSS nmos_rvt w=162.00n l=20n nfin=6
MM6 Y net29 net015 VSS nmos_rvt w=162.00n l=20n nfin=6
MM2 net29 B net43 VSS nmos_rvt w=81.0n l=20n nfin=3
MM3 net43 A VSS VSS nmos_rvt w=81.0n l=20n nfin=3
MM11 net041 A VDD VDD pmos_rvt w=162.00n l=20n nfin=6
MM10 Y B net041 VDD pmos_rvt w=162.00n l=20n nfin=6
MM9 Y net29 VDD VDD pmos_rvt w=162.00n l=20n nfin=6
MM0 net29 A VDD VDD pmos_rvt w=81.0n l=20n nfin=3
MM1 net29 B VDD VDD pmos_rvt w=81.0n l=20n nfin=3
.ENDS

.SUBCKT XNOR2x2_ASAP7_75t_R A B VDD VSS Y
M0 VSS N_M0_g N_M0_s VSS nmos_rvt L=2e-08 W=8.1e-08 nfin=3
M1 noxref_9 A VSS VSS nmos_rvt L=2e-08 W=8.1e-08 nfin=3
M2 N_M0_s B noxref_9 VSS nmos_rvt L=2e-08 W=8.1e-08 nfin=3
M3 N_M0_g B VSS VSS nmos_rvt L=2e-08 W=5.4e-08 nfin=2
M4 VSS A N_M0_g VSS nmos_rvt L=2e-08 W=5.4e-08 nfin=2
M5 Y N_M0_s VSS VSS nmos_rvt L=2e-08 W=8.1e-08 nfin=3
M6 Y N_M0_s VSS VSS nmos_rvt L=2e-08 W=8.1e-08 nfin=3
M7 noxref_7 N_M0_g N_M0_s VDD pmos_rvt L=2e-08 W=8.1e-08 nfin=3
M8 VDD A noxref_7 VDD pmos_rvt L=2e-08 W=8.1e-08 nfin=3
M9 noxref_7 B VDD VDD pmos_rvt L=2e-08 W=8.1e-08 nfin=3
M10 N_M10_d B N_M0_g VDD pmos_rvt L=2e-08 W=8.1e-08 nfin=3
M11 VDD A N_M10_d VDD pmos_rvt L=2e-08 W=8.1e-08 nfin=3
M12 Y N_M0_s VDD VDD pmos_rvt L=2e-08 W=8.1e-08 nfin=3
M13 Y N_M0_s VDD VDD pmos_rvt L=2e-08 W=8.1e-08 nfin=3
.ENDS

.SUBCKT XNOR2xp5_ASAP7_75t_R A B VDD VSS Y
MM4 net015 A VSS VSS nmos_rvt w=81.0n l=20n nfin=3
MM5 net015 B VSS VSS nmos_rvt w=81.0n l=20n nfin=3
MM6 Y net29 net015 VSS nmos_rvt w=81.0n l=20n nfin=3
MM2 net29 B net43 VSS nmos_rvt w=81.0n l=20n nfin=3
MM3 net43 A VSS VSS nmos_rvt w=81.0n l=20n nfin=3
MM11 net041 A VDD VDD pmos_rvt w=81.0n l=20n nfin=3
MM10 Y B net041 VDD pmos_rvt w=81.0n l=20n nfin=3
MM9 Y net29 VDD VDD pmos_rvt w=81.0n l=20n nfin=3
MM0 net29 A VDD VDD pmos_rvt w=54.0n l=20n nfin=2
MM1 net29 B VDD VDD pmos_rvt w=54.0n l=20n nfin=2
.ENDS

.SUBCKT XOR2x1_ASAP7_75t_R A B VDD VSS Y
MM11 VSS A net047 VSS nmos_rvt w=162.00n l=20n nfin=6
MM10 net047 B Y VSS nmos_rvt w=162.00n l=20n nfin=6
MM9 VSS net036 Y VSS nmos_rvt w=162.00n l=20n nfin=6
MM0 VSS A net036 VSS nmos_rvt w=81.0n l=20n nfin=3
MM1 VSS B net036 VSS nmos_rvt w=81.0n l=20n nfin=3
MM4 VDD A net019 VDD pmos_rvt w=162.00n l=20n nfin=6
MM5 VDD B net019 VDD pmos_rvt w=162.00n l=20n nfin=6
MM6 net019 net036 Y VDD pmos_rvt w=162.00n l=20n nfin=6
MM2 net048 B net036 VDD pmos_rvt w=81.0n l=20n nfin=3
MM3 VDD A net048 VDD pmos_rvt w=81.0n l=20n nfin=3
.ENDS

.SUBCKT XOR2x2_ASAP7_75t_R A B VDD VSS Y
M0 noxref_7 N_M0_g N_M0_s VSS nmos_rvt L=2e-08 W=8.1e-08 nfin=3
M1 VSS B noxref_7 VSS nmos_rvt L=2e-08 W=8.1e-08 nfin=3
M2 noxref_7 A VSS VSS nmos_rvt L=2e-08 W=8.1e-08 nfin=3
M3 N_M3_d A N_M0_g VSS nmos_rvt L=2e-08 W=8.1e-08 nfin=3
M4 VSS B N_M3_d VSS nmos_rvt L=2e-08 W=8.1e-08 nfin=3
M5 Y N_M0_s VSS VSS nmos_rvt L=2e-08 W=8.1e-08 nfin=3
M6 Y N_M0_s VSS VSS nmos_rvt L=2e-08 W=8.1e-08 nfin=3
M7 VDD N_M0_g N_M0_s VDD pmos_rvt L=2e-08 W=8.1e-08 nfin=3
M8 noxref_10 B VDD VDD pmos_rvt L=2e-08 W=8.1e-08 nfin=3
M9 N_M0_s A noxref_10 VDD pmos_rvt L=2e-08 W=8.1e-08 nfin=3
M10 N_M0_g A VDD VDD pmos_rvt L=2e-08 W=5.4e-08 nfin=2
M11 VDD B N_M0_g VDD pmos_rvt L=2e-08 W=5.4e-08 nfin=2
M12 Y N_M0_s VDD VDD pmos_rvt L=2e-08 W=8.1e-08 nfin=3
M13 Y N_M0_s VDD VDD pmos_rvt L=2e-08 W=8.1e-08 nfin=3
.ENDS

.SUBCKT XOR2xp5_ASAP7_75t_R A B VDD VSS Y
MM11 VSS A net047 VSS nmos_rvt w=81.0n l=20n nfin=3
MM10 net047 B Y VSS nmos_rvt w=81.0n l=20n nfin=3
MM9 VSS net036 Y VSS nmos_rvt w=81.0n l=20n nfin=3
MM0 VSS A net036 VSS nmos_rvt w=54.0n l=20n nfin=2
MM1 VSS B net036 VSS nmos_rvt w=54.0n l=20n nfin=2
MM4 VDD A net019 VDD pmos_rvt w=81.0n l=20n nfin=3
MM5 VDD B net019 VDD pmos_rvt w=81.0n l=20n nfin=3
MM6 net019 net036 Y VDD pmos_rvt w=81.0n l=20n nfin=3
MM2 net048 B net036 VDD pmos_rvt w=81.0n l=20n nfin=3
MM3 VDD A net048 VDD pmos_rvt w=81.0n l=20n nfin=3
.ENDS

* Physical well/substrate tap, no transistor devices.
.SUBCKT TAPCELL_ASAP7_75t_R VDD VSS
.ENDS TAPCELL_ASAP7_75t_R

* Physical filler without active devices.
.SUBCKT FILLER_ASAP7_75t_R VDD VSS
.ENDS FILLER_ASAP7_75t_R

* Physical filler without active devices.
.SUBCKT FILLERxp5_ASAP7_75t_R VDD VSS
.ENDS FILLERxp5_ASAP7_75t_R
* CDL Netlist generated by OpenROAD

*.BUSDELIMITER [

.SUBCKT gcd clk req_msg[0] req_msg[10] req_msg[11] req_msg[12]
+ req_msg[13] req_msg[14] req_msg[15] req_msg[16] req_msg[17]
+ req_msg[18] req_msg[19] req_msg[1] req_msg[20] req_msg[21]
+ req_msg[22] req_msg[23] req_msg[24] req_msg[25] req_msg[26]
+ req_msg[27] req_msg[28] req_msg[29] req_msg[2] req_msg[30]
+ req_msg[31] req_msg[3] req_msg[4] req_msg[5] req_msg[6] req_msg[7]
+ req_msg[8] req_msg[9] req_rdy req_val reset resp_msg[0] resp_msg[10]
+ resp_msg[11] resp_msg[12] resp_msg[13] resp_msg[14] resp_msg[15]
+ resp_msg[1] resp_msg[2] resp_msg[3] resp_msg[4] resp_msg[5]
+ resp_msg[6] resp_msg[7] resp_msg[8] resp_msg[9] resp_rdy resp_val
+ VDD VSS
X_331_ _001_ VDD VSS dpath.a_lt_b$in0\[15\] INVx1_ASAP7_75t_R
X_332_ _019_ VDD VSS dpath.a_lt_b$in0\[1\] INVx1_ASAP7_75t_R
X_333_ _003_ VDD VSS dpath.a_lt_b$in0\[2\] INVx1_ASAP7_75t_R
X_334_ _004_ VDD VSS dpath.a_lt_b$in0\[3\] INVx1_ASAP7_75t_R
X_335_ _005_ VDD VSS dpath.a_lt_b$in0\[4\] INVx1_ASAP7_75t_R
X_336_ _006_ VDD VSS dpath.a_lt_b$in0\[5\] INVx1_ASAP7_75t_R
X_337_ _007_ VDD VSS dpath.a_lt_b$in0\[6\] INVx1_ASAP7_75t_R
X_338_ _008_ VDD VSS dpath.a_lt_b$in0\[7\] INVx1_ASAP7_75t_R
X_339_ _009_ VDD VSS dpath.a_lt_b$in0\[8\] INVx1_ASAP7_75t_R
X_340_ _010_ VDD VSS dpath.a_lt_b$in0\[9\] INVx1_ASAP7_75t_R
X_341_ _011_ VDD VSS dpath.a_lt_b$in0\[10\] INVx1_ASAP7_75t_R
X_342_ _012_ VDD VSS dpath.a_lt_b$in0\[11\] INVx1_ASAP7_75t_R
X_343_ _013_ VDD VSS dpath.a_lt_b$in0\[12\] INVx1_ASAP7_75t_R
X_344_ _014_ VDD VSS dpath.a_lt_b$in0\[13\] INVx1_ASAP7_75t_R
X_345_ _015_ VDD VSS dpath.a_lt_b$in0\[14\] INVx1_ASAP7_75t_R
X_346_ _069_ VDD VSS dpath.a_lt_b$in1\[0\] INVx1_ASAP7_75t_R
X_347_ _021_ VDD VSS dpath.a_lt_b$in1\[1\] INVx1_ASAP7_75t_R
X_348_ _020_ VDD VSS _018_ INVx1_ASAP7_75t_R
X_349_ _000_ VDD VSS _108_ INVx1_ASAP7_75t_R
X_350_ _108_ _063_ _062_ VDD VSS _109_ OA21x2_ASAP7_75t_R
X_351_ _036_ _039_ _042_ VDD VSS _110_ OR3x1_ASAP7_75t_R
X_352_ _039_ _041_ _038_ VDD VSS _111_ OA21x2_ASAP7_75t_R
X_353_ _036_ _111_ _035_ VDD VSS _112_ OA21x2_ASAP7_75t_R
X_354_ _109_ _110_ _112_ VDD VSS _113_ OA21x2_ASAP7_75t_R
X_355_ _027_ _113_ VDD VSS net49 XOR2x2_ASAP7_75t_R
X_356_ _018_ _072_ _071_ VDD VSS _114_ OA21x2_ASAP7_75t_R
X_357_ _063_ _114_ _062_ VDD VSS _115_ OA21x2_ASAP7_75t_R
X_358_ _039_ _042_ VDD VSS _116_ OR2x2_ASAP7_75t_R
X_359_ _115_ _116_ _111_ VDD VSS _117_ OA21x2_ASAP7_75t_R
X_360_ _036_ _117_ VDD VSS net48 XOR2x2_ASAP7_75t_R
X_361_ _042_ _109_ _041_ VDD VSS _118_ OA21x2_ASAP7_75t_R
X_362_ _039_ _118_ VDD VSS net47 XOR2x2_ASAP7_75t_R
X_363_ _042_ _115_ VDD VSS net46 XOR2x2_ASAP7_75t_R
X_364_ _000_ _063_ VDD VSS net45 XNOR2x2_ASAP7_75t_R
X_365_ _070_ VDD VSS dpath.a_lt_b$in0\[0\] INVx1_ASAP7_75t_R
Xinput17 req_msg[24] VDD VSS net17 BUFx2_ASAP7_75t_R
X_367_ net56 VDD VSS net36 INVx1_ASAP7_75t_R
Xinput16 req_msg[23] VDD VSS net16 BUFx2_ASAP7_75t_R
Xinput15 req_msg[22] VDD VSS net15 BUFx2_ASAP7_75t_R
Xinput14 req_msg[21] VDD VSS net14 BUFx2_ASAP7_75t_R
X_371_ _030_ _033_ VDD VSS _124_ OR2x2_ASAP7_75t_R
X_372_ _057_ _051_ _060_ _124_ VDD VSS _125_ OR4x1_ASAP7_75t_R
X_373_ _027_ _125_ VDD VSS _126_ OR2x2_ASAP7_75t_R
X_374_ _026_ _033_ _032_ VDD VSS _127_ OA21x2_ASAP7_75t_R
X_375_ _057_ _030_ _051_ _060_ _127_ VDD VSS _128_ OR5x1_ASAP7_75t_R
X_376_ _056_ _051_ _128_ _050_ VDD VSS _129_ OA211x2_ASAP7_75t_R
X_377_ _029_ _060_ _059_ VDD VSS _130_ OA21x2_ASAP7_75t_R
X_378_ _057_ _051_ _130_ VDD VSS _131_ OR3x4_ASAP7_75t_R
X_379_ _113_ _126_ _129_ _131_ VDD VSS _132_ OA211x2_ASAP7_75t_R
X_380_ _045_ _024_ VDD VSS _133_ OR2x2_ASAP7_75t_R
X_381_ _054_ _048_ _133_ VDD VSS _134_ OR3x2_ASAP7_75t_R
Xinput13 req_msg[20] VDD VSS net13 BUFx2_ASAP7_75t_R
X_383_ _002_ VDD VSS _136_ INVx1_ASAP7_75t_R
X_384_ _044_ _024_ _023_ VDD VSS _137_ OA21x2_ASAP7_75t_R
X_385_ _048_ _137_ _047_ VDD VSS _138_ OA21x2_ASAP7_75t_R
X_386_ _054_ _138_ _053_ VDD VSS _139_ OA21x2_ASAP7_75t_R
X_387_ _136_ _139_ VDD VSS _140_ AND2x2_ASAP7_75t_R
X_388_ _132_ _134_ _140_ VDD VSS _141_ OAI21x1_ASAP7_75t_R
Xinput12 req_msg[1] VDD VSS net12 BUFx2_ASAP7_75t_R
X_390_ net36 _141_ VDD VSS _067_ OR2x4_ASAP7_75t_R
X_391_ _067_ VDD VSS ctrl$a_mux_sel\[1\] INVx2_ASAP7_75t_R
X_392_ _132_ _133_ _137_ VDD VSS _143_ OA21x2_ASAP7_75t_R
X_393_ _048_ _143_ VDD VSS net42 XOR2x2_ASAP7_75t_R
X_394_ _027_ _036_ _125_ VDD VSS _144_ OR3x1_ASAP7_75t_R
X_395_ _059_ _057_ _056_ VDD VSS _145_ OA21x2_ASAP7_75t_R
X_396_ _027_ _035_ _026_ VDD VSS _146_ OA21x2_ASAP7_75t_R
X_397_ _030_ _032_ _029_ VDD VSS _147_ OA21x2_ASAP7_75t_R
X_398_ _124_ _146_ _147_ VDD VSS _148_ OA21x2_ASAP7_75t_R
X_399_ _057_ _051_ _060_ _148_ VDD VSS _149_ OR4x1_ASAP7_75t_R
X_400_ _051_ _145_ _149_ VDD VSS _150_ OA21x2_ASAP7_75t_R
X_401_ _117_ _144_ _150_ VDD VSS _151_ OAI21x1_ASAP7_75t_R
X_402_ _045_ VDD VSS _152_ INVx1_ASAP7_75t_R
X_403_ _152_ _024_ VDD VSS _153_ AND2x2_ASAP7_75t_R
X_404_ _050_ _045_ _044_ VDD VSS _154_ OAI21x1_ASAP7_75t_R
X_405_ _024_ _154_ VDD VSS _155_ NOR2x1_ASAP7_75t_R
X_406_ _117_ _144_ _155_ _150_ VDD VSS _156_ OA211x2_ASAP7_75t_R
X_407_ _151_ _153_ _156_ VDD VSS _157_ AO21x1_ASAP7_75t_R
X_408_ _024_ _154_ VDD VSS _158_ AND2x2_ASAP7_75t_R
X_409_ _045_ _155_ _158_ VDD VSS _159_ AO21x1_ASAP7_75t_R
X_410_ _157_ _159_ VDD VSS net41 OR2x2_ASAP7_75t_R
X_411_ _152_ _132_ VDD VSS net40 XNOR2x2_ASAP7_75t_R
X_412_ _051_ VDD VSS _160_ INVx1_ASAP7_75t_R
X_413_ _057_ _060_ _124_ VDD VSS _161_ OR3x1_ASAP7_75t_R
X_414_ _115_ _116_ _146_ _111_ VDD VSS _162_ OA211x2_ASAP7_75t_R
X_415_ _027_ _036_ _146_ VDD VSS _163_ OA21x2_ASAP7_75t_R
X_416_ _162_ _163_ VDD VSS _164_ OR2x2_ASAP7_75t_R
X_417_ _060_ _147_ _059_ VDD VSS _165_ OA21x2_ASAP7_75t_R
X_418_ _057_ _165_ _056_ VDD VSS _166_ OA21x2_ASAP7_75t_R
X_419_ _161_ _164_ _166_ VDD VSS _167_ OA21x2_ASAP7_75t_R
X_420_ _160_ _167_ VDD VSS net39 XNOR2x2_ASAP7_75t_R
X_421_ _060_ VDD VSS _168_ INVx1_ASAP7_75t_R
X_422_ _032_ _033_ _030_ VDD VSS _169_ AO21x1_ASAP7_75t_R
X_423_ _027_ _113_ _032_ _026_ VDD VSS _170_ OA211x2_ASAP7_75t_R
X_424_ _169_ _170_ _029_ VDD VSS _171_ OAI21x1_ASAP7_75t_R
X_425_ _059_ VDD VSS _172_ INVx1_ASAP7_75t_R
X_426_ _168_ _171_ _172_ VDD VSS _173_ AO21x1_ASAP7_75t_R
X_427_ _057_ _173_ VDD VSS net38 XNOR2x2_ASAP7_75t_R
X_428_ _124_ _162_ _163_ _147_ VDD VSS _174_ OA31x2_ASAP7_75t_R
X_429_ _168_ _174_ VDD VSS net52 XNOR2x2_ASAP7_75t_R
X_430_ _027_ _113_ _026_ VDD VSS _175_ OA21x2_ASAP7_75t_R
X_431_ _033_ _175_ _032_ VDD VSS _176_ OAI21x1_ASAP7_75t_R
X_432_ _030_ _176_ VDD VSS net51 XNOR2x2_ASAP7_75t_R
X_433_ _033_ _164_ VDD VSS net50 XOR2x2_ASAP7_75t_R
X_434_ _048_ _125_ _133_ VDD VSS _177_ OR3x1_ASAP7_75t_R
X_435_ _051_ _048_ _133_ VDD VSS _178_ OR3x1_ASAP7_75t_R
X_436_ _050_ _045_ _044_ VDD VSS _179_ OA21x2_ASAP7_75t_R
X_437_ _024_ _179_ _023_ VDD VSS _180_ OA21x2_ASAP7_75t_R
X_438_ _048_ _180_ _047_ VDD VSS _181_ OA21x2_ASAP7_75t_R
X_439_ _166_ _178_ _181_ VDD VSS _182_ OA21x2_ASAP7_75t_R
X_440_ _162_ _163_ _177_ _182_ VDD VSS _183_ OA31x2_ASAP7_75t_R
X_441_ _054_ _183_ VDD VSS net43 XOR2x2_ASAP7_75t_R
X_442_ _132_ _134_ _139_ VDD VSS _184_ OA21x2_ASAP7_75t_R
X_443_ _002_ net36 _184_ VDD VSS _064_ OR3x1_ASAP7_75t_R
X_444_ _064_ VDD VSS ctrl$a_mux_sel\[0\] INVx1_ASAP7_75t_R
Xinput11 req_msg[19] VDD VSS net11 BUFx2_ASAP7_75t_R
X_446_ _136_ _184_ VDD VSS _185_ AND2x4_ASAP7_75t_R
Xinput10 req_msg[18] VDD VSS net10 BUFx2_ASAP7_75t_R
Xinput9 req_msg[17] VDD VSS net9 BUFx2_ASAP7_75t_R
X_449_ dpath.a_lt_b$in0\[14\] net56 VDD VSS _188_ AND2x2_ASAP7_75t_R
X_450_ _046_ VDD VSS _189_ INVx1_ASAP7_75t_R
Xinput8 req_msg[16] VDD VSS net8 BUFx2_ASAP7_75t_R
X_452_ _189_ net56 _141_ VDD VSS _191_ AND3x1_ASAP7_75t_R
X_453_ net6 net36 _185_ _188_ _191_ VDD VSS _076_ AO221x2_ASAP7_75t_R
X_454_ dpath.a_lt_b$in0\[13\] net56 VDD VSS _192_ AND2x2_ASAP7_75t_R
X_455_ _022_ VDD VSS _193_ INVx1_ASAP7_75t_R
X_456_ _193_ net56 _141_ VDD VSS _194_ AND3x1_ASAP7_75t_R
X_457_ net36 net5 _185_ _192_ _194_ VDD VSS _077_ AO221x2_ASAP7_75t_R
X_458_ dpath.a_lt_b$in0\[12\] net56 VDD VSS _195_ AND2x2_ASAP7_75t_R
X_459_ _043_ VDD VSS _196_ INVx1_ASAP7_75t_R
X_460_ _196_ net56 _141_ VDD VSS _197_ AND3x1_ASAP7_75t_R
X_461_ net36 net4 _185_ _195_ _197_ VDD VSS _078_ AO221x2_ASAP7_75t_R
X_462_ dpath.a_lt_b$in0\[11\] net56 VDD VSS _198_ AND2x2_ASAP7_75t_R
X_463_ _049_ VDD VSS _199_ INVx1_ASAP7_75t_R
X_464_ _199_ net56 _141_ VDD VSS _200_ AND3x1_ASAP7_75t_R
X_465_ net36 net3 _185_ _198_ _200_ VDD VSS _079_ AO221x2_ASAP7_75t_R
Xinput7 req_msg[15] VDD VSS net7 BUFx2_ASAP7_75t_R
X_467_ dpath.a_lt_b$in0\[10\] net56 VDD VSS _202_ AND2x2_ASAP7_75t_R
X_468_ _055_ VDD VSS _203_ INVx1_ASAP7_75t_R
X_469_ _203_ net56 _141_ VDD VSS _204_ AND3x1_ASAP7_75t_R
X_470_ net36 net2 _185_ _202_ _204_ VDD VSS _080_ AO221x2_ASAP7_75t_R
X_471_ dpath.a_lt_b$in0\[9\] net56 VDD VSS _205_ AND2x2_ASAP7_75t_R
X_472_ _058_ VDD VSS _206_ INVx1_ASAP7_75t_R
X_473_ _206_ net56 _141_ VDD VSS _207_ AND3x1_ASAP7_75t_R
X_474_ net36 net32 _185_ _205_ _207_ VDD VSS _081_ AO221x2_ASAP7_75t_R
X_475_ dpath.a_lt_b$in0\[8\] net56 VDD VSS _208_ AND2x2_ASAP7_75t_R
X_476_ _028_ VDD VSS _209_ INVx1_ASAP7_75t_R
X_477_ _209_ net56 _141_ VDD VSS _210_ AND3x1_ASAP7_75t_R
X_478_ net36 net31 _185_ _208_ _210_ VDD VSS _082_ AO221x2_ASAP7_75t_R
X_479_ dpath.a_lt_b$in0\[7\] net56 VDD VSS _211_ AND2x2_ASAP7_75t_R
X_480_ _031_ VDD VSS _212_ INVx1_ASAP7_75t_R
X_481_ _212_ net56 _141_ VDD VSS _213_ AND3x1_ASAP7_75t_R
X_482_ net36 net30 _185_ _211_ _213_ VDD VSS _083_ AO221x2_ASAP7_75t_R
X_483_ dpath.a_lt_b$in0\[6\] net56 VDD VSS _214_ AND2x2_ASAP7_75t_R
X_484_ _025_ VDD VSS _215_ INVx1_ASAP7_75t_R
X_485_ _215_ net56 _141_ VDD VSS _216_ AND3x1_ASAP7_75t_R
X_486_ net36 net29 _185_ _214_ _216_ VDD VSS _084_ AO221x1_ASAP7_75t_R
X_487_ dpath.a_lt_b$in0\[5\] net56 VDD VSS _217_ AND2x2_ASAP7_75t_R
X_488_ _034_ VDD VSS _218_ INVx1_ASAP7_75t_R
X_489_ _218_ net56 _141_ VDD VSS _219_ AND3x1_ASAP7_75t_R
X_490_ net36 net28 _185_ _217_ _219_ VDD VSS _085_ AO221x1_ASAP7_75t_R
X_491_ dpath.a_lt_b$in0\[4\] net56 VDD VSS _220_ AND2x2_ASAP7_75t_R
X_492_ _037_ VDD VSS _221_ INVx1_ASAP7_75t_R
X_493_ _221_ net56 _141_ VDD VSS _222_ AND3x1_ASAP7_75t_R
X_494_ net36 net27 _185_ _220_ _222_ VDD VSS _086_ AO221x1_ASAP7_75t_R
X_495_ dpath.a_lt_b$in0\[3\] net56 VDD VSS _223_ AND2x2_ASAP7_75t_R
X_496_ _040_ VDD VSS _224_ INVx1_ASAP7_75t_R
X_497_ _224_ net56 _141_ VDD VSS _225_ AND3x1_ASAP7_75t_R
X_498_ net36 net26 _185_ _223_ _225_ VDD VSS _087_ AO221x1_ASAP7_75t_R
X_499_ dpath.a_lt_b$in0\[2\] net56 VDD VSS _226_ AND2x2_ASAP7_75t_R
X_500_ _061_ VDD VSS _227_ INVx1_ASAP7_75t_R
X_501_ _227_ net56 _141_ VDD VSS _228_ AND3x1_ASAP7_75t_R
X_502_ net36 net23 _185_ _226_ _228_ VDD VSS _088_ AO221x1_ASAP7_75t_R
X_503_ dpath.a_lt_b$in0\[1\] net56 VDD VSS _229_ AND2x2_ASAP7_75t_R
X_504_ dpath.a_lt_b$in1\[1\] net56 _141_ VDD VSS _230_ AND3x1_ASAP7_75t_R
X_505_ net36 net12 _185_ _229_ _230_ VDD VSS _089_ AO221x1_ASAP7_75t_R
X_506_ dpath.a_lt_b$in0\[0\] net56 VDD VSS _231_ AND2x2_ASAP7_75t_R
X_507_ dpath.a_lt_b$in1\[0\] net56 _141_ VDD VSS _232_ AND3x1_ASAP7_75t_R
X_508_ net36 net1 _185_ _231_ _232_ VDD VSS _090_ AO221x1_ASAP7_75t_R
X_509_ _002_ net56 VDD VSS _233_ AND2x2_ASAP7_75t_R
Xinput6 req_msg[14] VDD VSS net6 BUFx2_ASAP7_75t_R
Xinput5 req_msg[13] VDD VSS net5 BUFx2_ASAP7_75t_R
Xinput4 req_msg[12] VDD VSS net4 BUFx2_ASAP7_75t_R
X_513_ _068_ VDD VSS _237_ INVx1_ASAP7_75t_R
X_514_ _002_ net56 VDD VSS _238_ NAND2x1_ASAP7_75t_R
X_515_ _237_ _238_ VDD VSS _239_ AND2x2_ASAP7_75t_R
X_516_ net24 net55 _239_ VDD VSS _240_ OA21x2_ASAP7_75t_R
X_517_ net55 VDD VSS _241_ INVx1_ASAP7_75t_R
Xinput3 req_msg[11] VDD VSS net3 BUFx2_ASAP7_75t_R
X_519_ net24 _241_ VDD VSS _243_ AND2x2_ASAP7_75t_R
X_520_ _065_ VDD VSS _244_ INVx1_ASAP7_75t_R
Xinput2 req_msg[10] VDD VSS net2 BUFx2_ASAP7_75t_R
X_522_ _189_ _244_ net55 VDD VSS _246_ AND3x1_ASAP7_75t_R
Xinput1 req_msg[0] VDD VSS net1 BUFx2_ASAP7_75t_R
X_524_ _243_ _246_ _238_ VDD VSS _248_ OA21x2_ASAP7_75t_R
X_525_ dpath.a_lt_b$in0\[14\] _233_ _240_ net42 _248_ VDD
+ VSS _091_ AO221x1_ASAP7_75t_R
X_526_ _066_ net22 _239_ VDD VSS _249_ OA21x2_ASAP7_75t_R
X_527_ _241_ net22 VDD VSS _250_ AND2x2_ASAP7_75t_R
X_528_ _193_ _244_ _066_ VDD VSS _251_ AND3x1_ASAP7_75t_R
X_529_ _250_ _251_ _238_ VDD VSS _252_ OA21x2_ASAP7_75t_R
X_530_ dpath.a_lt_b$in0\[13\] _233_ _249_ _159_ _252_ VDD
+ VSS _253_ AO221x1_ASAP7_75t_R
X_531_ _157_ _249_ _253_ VDD VSS _092_ AO21x1_ASAP7_75t_R
X_532_ _066_ _238_ VDD VSS _254_ AND2x2_ASAP7_75t_R
X_533_ _043_ _065_ _254_ VDD VSS _255_ OAI21x1_ASAP7_75t_R
X_534_ _237_ net40 _255_ VDD VSS _256_ AO21x1_ASAP7_75t_R
X_535_ net55 net21 _238_ VDD VSS _257_ OA21x2_ASAP7_75t_R
X_536_ dpath.a_lt_b$in0\[12\] _233_ _257_ VDD VSS _258_ AO21x1_ASAP7_75t_R
X_537_ _256_ _258_ VDD VSS _093_ AND2x2_ASAP7_75t_R
X_538_ _066_ net20 _233_ VDD VSS _259_ OR3x1_ASAP7_75t_R
X_539_ dpath.a_lt_b$in0\[11\] _238_ _259_ VDD VSS _260_ OAI21x1_ASAP7_75t_R
X_540_ _068_ _051_ _260_ VDD VSS _261_ OR3x1_ASAP7_75t_R
X_541_ _261_ VDD VSS _262_ INVx1_ASAP7_75t_R
X_542_ _161_ _164_ _262_ _166_ VDD VSS _263_ OA211x2_ASAP7_75t_R
X_543_ _068_ _160_ _260_ VDD VSS _264_ OR3x1_ASAP7_75t_R
X_544_ _161_ _164_ _264_ VDD VSS _265_ NOR3x1_ASAP7_75t_R
X_545_ _049_ _065_ _254_ VDD VSS _266_ OA21x2_ASAP7_75t_R
X_546_ _260_ _266_ _264_ _166_ VDD VSS _267_ OAI22x1_ASAP7_75t_R
X_547_ _263_ _265_ _267_ VDD VSS _094_ OR3x1_ASAP7_75t_R
X_548_ _169_ _170_ _029_ VDD VSS _268_ OA21x2_ASAP7_75t_R
X_549_ _057_ VDD VSS _269_ INVx1_ASAP7_75t_R
X_550_ _066_ net19 _239_ VDD VSS _270_ OA21x2_ASAP7_75t_R
X_551_ _059_ _269_ _270_ VDD VSS _271_ AND3x1_ASAP7_75t_R
X_552_ _057_ _168_ VDD VSS _272_ AND2x2_ASAP7_75t_R
X_553_ _059_ _269_ _060_ VDD VSS _273_ AND3x1_ASAP7_75t_R
X_554_ _172_ _057_ _171_ _272_ _273_ VDD VSS _274_ AO221x1_ASAP7_75t_R
X_555_ _241_ net19 VDD VSS _275_ AND2x2_ASAP7_75t_R
X_556_ _203_ _244_ net55 VDD VSS _276_ AND3x1_ASAP7_75t_R
X_557_ _275_ _276_ _238_ VDD VSS _277_ OA21x2_ASAP7_75t_R
X_558_ dpath.a_lt_b$in0\[10\] _233_ _277_ VDD VSS _278_ AO21x1_ASAP7_75t_R
X_559_ _268_ _271_ _274_ _270_ _278_ VDD VSS _095_ AO221x1_ASAP7_75t_R
X_560_ net55 net18 VDD VSS _279_ OR2x2_ASAP7_75t_R
X_561_ _206_ _244_ net55 VDD VSS _280_ AND3x1_ASAP7_75t_R
X_562_ _241_ net18 net56 _002_ _280_ VDD VSS _281_ AO221x1_ASAP7_75t_R
X_563_ _010_ _233_ VDD VSS _282_ NAND2x1_ASAP7_75t_R
X_564_ net52 _239_ _279_ _281_ _282_ VDD VSS _096_ AO32x1_ASAP7_75t_R
X_565_ _066_ net17 _238_ VDD VSS _283_ OAI21x1_ASAP7_75t_R
X_566_ _009_ _238_ _283_ VDD VSS _284_ OA21x2_ASAP7_75t_R
X_567_ _028_ _065_ _254_ VDD VSS _285_ OA21x2_ASAP7_75t_R
X_568_ _284_ _285_ VDD VSS _286_ NOR2x1_ASAP7_75t_R
X_569_ _284_ VDD VSS _287_ INVx1_ASAP7_75t_R
X_570_ _030_ _237_ _176_ _287_ VDD VSS _288_ AND4x1_ASAP7_75t_R
X_571_ _030_ _068_ _284_ VDD VSS _289_ OR3x1_ASAP7_75t_R
X_572_ _176_ _289_ VDD VSS _290_ NOR2x1_ASAP7_75t_R
X_573_ _286_ _288_ _290_ VDD VSS _097_ OR3x1_ASAP7_75t_R
X_574_ _066_ net16 _233_ VDD VSS _291_ OR3x1_ASAP7_75t_R
X_575_ dpath.a_lt_b$in0\[7\] _238_ _291_ VDD VSS _292_ OAI21x1_ASAP7_75t_R
X_576_ _068_ _292_ VDD VSS _293_ NOR2x1_ASAP7_75t_R
X_577_ _031_ _065_ _254_ VDD VSS _294_ OA21x2_ASAP7_75t_R
X_578_ _292_ _294_ VDD VSS _295_ NOR2x1_ASAP7_75t_R
X_579_ net50 _293_ _295_ VDD VSS _098_ AO21x1_ASAP7_75t_R
X_580_ _215_ _244_ net49 _237_ _241_ VDD VSS _296_ AO221x1_ASAP7_75t_R
X_581_ _066_ net15 _238_ _296_ VDD VSS _297_ OA211x2_ASAP7_75t_R
X_582_ dpath.a_lt_b$in0\[6\] _233_ _297_ VDD VSS _099_ AO21x1_ASAP7_75t_R
X_583_ _034_ _065_ _254_ VDD VSS _298_ OAI21x1_ASAP7_75t_R
X_584_ _237_ net48 _298_ VDD VSS _299_ AO21x1_ASAP7_75t_R
X_585_ _066_ net14 _238_ VDD VSS _300_ OA21x2_ASAP7_75t_R
X_586_ dpath.a_lt_b$in0\[5\] _233_ _300_ VDD VSS _301_ AO21x1_ASAP7_75t_R
X_587_ _299_ _301_ VDD VSS _100_ AND2x2_ASAP7_75t_R
X_588_ _221_ _244_ net47 _237_ _241_ VDD VSS _302_ AO221x1_ASAP7_75t_R
X_589_ _066_ net13 _238_ _302_ VDD VSS _303_ OA211x2_ASAP7_75t_R
X_590_ dpath.a_lt_b$in0\[4\] _233_ _303_ VDD VSS _101_ AO21x1_ASAP7_75t_R
X_591_ _224_ _244_ net46 _237_ _241_ VDD VSS _304_ AO221x1_ASAP7_75t_R
X_592_ _066_ net11 _238_ _304_ VDD VSS _305_ OA211x2_ASAP7_75t_R
X_593_ dpath.a_lt_b$in0\[3\] _233_ _305_ VDD VSS _102_ AO21x1_ASAP7_75t_R
X_594_ _227_ _244_ net45 _237_ VDD VSS _306_ AO22x1_ASAP7_75t_R
X_595_ net55 net10 VDD VSS _307_ OR2x2_ASAP7_75t_R
X_596_ _241_ _306_ _307_ _238_ VDD VSS _308_ OA211x2_ASAP7_75t_R
X_597_ dpath.a_lt_b$in0\[2\] _233_ _308_ VDD VSS _103_ AO21x1_ASAP7_75t_R
X_598_ dpath.a_lt_b$in1\[1\] _244_ net44 _237_ _241_ VDD VSS
+ _309_ AO221x1_ASAP7_75t_R
X_599_ net55 net9 _238_ _309_ VDD VSS _310_ OA211x2_ASAP7_75t_R
X_600_ dpath.a_lt_b$in0\[1\] _233_ _310_ VDD VSS _104_ AO21x1_ASAP7_75t_R
X_601_ dpath.a_lt_b$in1\[0\] _244_ net37 _237_ _241_ VDD VSS
+ _311_ AO221x1_ASAP7_75t_R
X_602_ net55 net8 _238_ _311_ VDD VSS _312_ OA211x2_ASAP7_75t_R
X_603_ dpath.a_lt_b$in0\[0\] _233_ _312_ VDD VSS _105_ AO21x1_ASAP7_75t_R
X_604_ net33 VDD VSS _313_ INVx1_ASAP7_75t_R
X_605_ _017_ _238_ VDD VSS net53 NOR2x1_ASAP7_75t_R
X_606_ net36 _313_ net35 net53 net34 VDD VSS _073_ AO221x1_ASAP7_75t_R
X_607_ _031_ _028_ _058_ _046_ VDD VSS _314_ AND4x1_ASAP7_75t_R
X_608_ _055_ _049_ _043_ _022_ _314_ VDD VSS _315_ AND5x1_ASAP7_75t_R
X_609_ _052_ _069_ _021_ _025_ VDD VSS _316_ AND4x1_ASAP7_75t_R
X_610_ _061_ _040_ _037_ _034_ _316_ VDD VSS _317_ AND5x1_ASAP7_75t_R
X_611_ _315_ _317_ VDD VSS _318_ NAND2x1_ASAP7_75t_R
X_612_ _002_ _184_ _318_ VDD VSS _319_ OR3x1_ASAP7_75t_R
X_613_ net35 _233_ _319_ _017_ net34 VDD VSS _074_ AOI221x1_ASAP7_75t_R
X_614_ net36 net33 _318_ _136_ VDD VSS _320_ AOI22x1_ASAP7_75t_R
X_615_ _141_ _320_ net34 VDD VSS _075_ AOI21x1_ASAP7_75t_R
X_616_ dpath.a_lt_b$in0\[15\] net56 VDD VSS _321_ AND2x2_ASAP7_75t_R
X_617_ _052_ VDD VSS _322_ INVx1_ASAP7_75t_R
X_618_ _322_ net56 _141_ VDD VSS _323_ AND3x1_ASAP7_75t_R
X_619_ net36 net7 _185_ _321_ _323_ VDD VSS _106_ AO221x1_ASAP7_75t_R
X_620_ net55 net25 VDD VSS _324_ OR2x2_ASAP7_75t_R
X_621_ _322_ _244_ net55 VDD VSS _325_ AND3x1_ASAP7_75t_R
X_622_ _002_ net56 net25 _241_ _325_ VDD VSS _326_ AO221x1_ASAP7_75t_R
X_623_ _001_ _233_ VDD VSS _327_ NAND2x1_ASAP7_75t_R
X_624_ net43 _239_ _324_ _326_ _327_ VDD VSS _107_ AO32x1_ASAP7_75t_R
X_625_ _018_ dpath.a_lt_b$in1\[1\] _019_ _000_ net44 VDD VSS
+ FAx1_ASAP7_75t_R
X_626_ _022_ dpath.a_lt_b$in0\[13\] _023_ _024_ VDD VSS HAxp5_ASAP7_75t_R
X_627_ _025_ dpath.a_lt_b$in0\[6\] _026_ _027_ VDD VSS HAxp5_ASAP7_75t_R
X_628_ _028_ dpath.a_lt_b$in0\[8\] _029_ _030_ VDD VSS HAxp5_ASAP7_75t_R
X_629_ _031_ dpath.a_lt_b$in0\[7\] _032_ _033_ VDD VSS HAxp5_ASAP7_75t_R
X_630_ _034_ dpath.a_lt_b$in0\[5\] _035_ _036_ VDD VSS HAxp5_ASAP7_75t_R
X_631_ _037_ dpath.a_lt_b$in0\[4\] _038_ _039_ VDD VSS HAxp5_ASAP7_75t_R
X_632_ _040_ dpath.a_lt_b$in0\[3\] _041_ _042_ VDD VSS HAxp5_ASAP7_75t_R
X_633_ _043_ dpath.a_lt_b$in0\[12\] _044_ _045_ VDD VSS HAxp5_ASAP7_75t_R
X_634_ _046_ dpath.a_lt_b$in0\[14\] _047_ _048_ VDD VSS HAxp5_ASAP7_75t_R
X_635_ _049_ dpath.a_lt_b$in0\[11\] _050_ _051_ VDD VSS HAxp5_ASAP7_75t_R
X_636_ _052_ dpath.a_lt_b$in0\[15\] _053_ _054_ VDD VSS HAxp5_ASAP7_75t_R
X_637_ _055_ dpath.a_lt_b$in0\[10\] _056_ _057_ VDD VSS HAxp5_ASAP7_75t_R
X_638_ _058_ dpath.a_lt_b$in0\[9\] _059_ _060_ VDD VSS HAxp5_ASAP7_75t_R
X_639_ _061_ dpath.a_lt_b$in0\[2\] _062_ _063_ VDD VSS HAxp5_ASAP7_75t_R
X_640_ _064_ ctrl$a_mux_sel\[1\] _065_ _066_ VDD VSS HAxp5_ASAP7_75t_R
X_641_ ctrl$a_mux_sel\[0\] _067_ _068_ _328_ VDD VSS HAxp5_ASAP7_75t_R
X_642_ _069_ dpath.a_lt_b$in0\[0\] _329_ net37 VDD VSS HAxp5_ASAP7_75t_R
X_643_ dpath.a_lt_b$in1\[0\] _070_ _020_ _330_ VDD VSS HAxp5_ASAP7_75t_R
X_644_ _021_ dpath.a_lt_b$in0\[1\] _071_ _072_ VDD VSS HAxp5_ASAP7_75t_R
Xctrl.state.out\[0\]$_DFF_P_ clknet_2_0__leaf_clk _073_ _016_
+ VDD VSS DFFHQNx1_ASAP7_75t_R
Xctrl.state.out\[1\]$_DFF_P_ clknet_2_0__leaf_clk _074_ _017_
+ VDD VSS DFFHQNx1_ASAP7_75t_R
Xctrl.state.out\[2\]$_DFF_P_ clknet_2_0__leaf_clk _075_ _002_
+ VDD VSS DFFHQNx1_ASAP7_75t_R
Xdpath.a_reg.out\[0\]$_DFFE_PP_ clknet_2_2__leaf_clk _105_
+ _070_ VDD VSS DFFHQNx1_ASAP7_75t_R
Xdpath.a_reg.out\[10\]$_DFFE_PP_ clknet_2_1__leaf_clk _095_
+ _011_ VDD VSS DFFHQNx1_ASAP7_75t_R
Xdpath.a_reg.out\[11\]$_DFFE_PP_ clknet_2_1__leaf_clk _094_
+ _012_ VDD VSS DFFHQNx1_ASAP7_75t_R
Xdpath.a_reg.out\[12\]$_DFFE_PP_ clknet_2_2__leaf_clk _093_
+ _013_ VDD VSS DFFHQNx1_ASAP7_75t_R
Xdpath.a_reg.out\[13\]$_DFFE_PP_ clknet_2_3__leaf_clk _092_
+ _014_ VDD VSS DFFHQNx1_ASAP7_75t_R
Xdpath.a_reg.out\[14\]$_DFFE_PP_ clknet_2_0__leaf_clk _091_
+ _015_ VDD VSS DFFHQNx1_ASAP7_75t_R
Xdpath.a_reg.out\[15\]$_DFFE_PP_ clknet_2_2__leaf_clk _107_
+ _001_ VDD VSS DFFHQNx1_ASAP7_75t_R
Xdpath.a_reg.out\[1\]$_DFFE_PP_ clknet_2_2__leaf_clk _104_
+ _019_ VDD VSS DFFHQNx1_ASAP7_75t_R
Xdpath.a_reg.out\[2\]$_DFFE_PP_ clknet_2_3__leaf_clk _103_
+ _003_ VDD VSS DFFHQNx1_ASAP7_75t_R
Xdpath.a_reg.out\[3\]$_DFFE_PP_ clknet_2_3__leaf_clk _102_
+ _004_ VDD VSS DFFHQNx1_ASAP7_75t_R
Xdpath.a_reg.out\[4\]$_DFFE_PP_ clknet_2_3__leaf_clk _101_
+ _005_ VDD VSS DFFHQNx1_ASAP7_75t_R
Xdpath.a_reg.out\[5\]$_DFFE_PP_ clknet_2_3__leaf_clk _100_
+ _006_ VDD VSS DFFHQNx1_ASAP7_75t_R
Xdpath.a_reg.out\[6\]$_DFFE_PP_ clknet_2_3__leaf_clk _099_
+ _007_ VDD VSS DFFHQNx1_ASAP7_75t_R
Xdpath.a_reg.out\[7\]$_DFFE_PP_ clknet_2_1__leaf_clk _098_
+ _008_ VDD VSS DFFHQNx1_ASAP7_75t_R
Xdpath.a_reg.out\[8\]$_DFFE_PP_ clknet_2_1__leaf_clk _097_
+ _009_ VDD VSS DFFHQNx1_ASAP7_75t_R
Xdpath.a_reg.out\[9\]$_DFFE_PP_ clknet_2_0__leaf_clk _096_
+ _010_ VDD VSS DFFHQNx1_ASAP7_75t_R
Xdpath.b_reg.out\[0\]$_DFFE_PP_ clknet_2_2__leaf_clk _090_
+ _069_ VDD VSS DFFHQNx1_ASAP7_75t_R
Xdpath.b_reg.out\[10\]$_DFFE_PP_ clknet_2_1__leaf_clk _080_
+ _055_ VDD VSS DFFHQNx1_ASAP7_75t_R
Xdpath.b_reg.out\[11\]$_DFFE_PP_ clknet_2_0__leaf_clk _079_
+ _049_ VDD VSS DFFHQNx1_ASAP7_75t_R
Xdpath.b_reg.out\[12\]$_DFFE_PP_ clknet_2_0__leaf_clk _078_
+ _043_ VDD VSS DFFHQNx1_ASAP7_75t_R
Xdpath.b_reg.out\[13\]$_DFFE_PP_ clknet_2_2__leaf_clk _077_
+ _022_ VDD VSS DFFHQNx1_ASAP7_75t_R
Xdpath.b_reg.out\[14\]$_DFFE_PP_ clknet_2_0__leaf_clk _076_
+ _046_ VDD VSS DFFHQNx1_ASAP7_75t_R
Xdpath.b_reg.out\[15\]$_DFFE_PP_ clknet_2_2__leaf_clk _106_
+ _052_ VDD VSS DFFHQNx1_ASAP7_75t_R
Xdpath.b_reg.out\[1\]$_DFFE_PP_ clknet_2_2__leaf_clk _089_
+ _021_ VDD VSS DFFHQNx1_ASAP7_75t_R
Xdpath.b_reg.out\[2\]$_DFFE_PP_ clknet_2_2__leaf_clk _088_
+ _061_ VDD VSS DFFHQNx1_ASAP7_75t_R
Xdpath.b_reg.out\[3\]$_DFFE_PP_ clknet_2_3__leaf_clk _087_
+ _040_ VDD VSS DFFHQNx1_ASAP7_75t_R
Xdpath.b_reg.out\[4\]$_DFFE_PP_ clknet_2_3__leaf_clk _086_
+ _037_ VDD VSS DFFHQNx1_ASAP7_75t_R
Xdpath.b_reg.out\[5\]$_DFFE_PP_ clknet_2_2__leaf_clk _085_
+ _034_ VDD VSS DFFHQNx1_ASAP7_75t_R
Xdpath.b_reg.out\[6\]$_DFFE_PP_ clknet_2_3__leaf_clk _084_
+ _025_ VDD VSS DFFHQNx1_ASAP7_75t_R
Xdpath.b_reg.out\[7\]$_DFFE_PP_ clknet_2_1__leaf_clk _083_
+ _031_ VDD VSS DFFHQNx1_ASAP7_75t_R
Xdpath.b_reg.out\[8\]$_DFFE_PP_ clknet_2_1__leaf_clk _082_
+ _028_ VDD VSS DFFHQNx1_ASAP7_75t_R
Xdpath.b_reg.out\[9\]$_DFFE_PP_ clknet_2_0__leaf_clk _081_
+ _058_ VDD VSS DFFHQNx1_ASAP7_75t_R
Xinput18 req_msg[25] VDD VSS net18 BUFx2_ASAP7_75t_R
Xinput19 req_msg[26] VDD VSS net19 BUFx2_ASAP7_75t_R
Xinput20 req_msg[27] VDD VSS net20 BUFx2_ASAP7_75t_R
Xinput21 req_msg[28] VDD VSS net21 BUFx2_ASAP7_75t_R
Xinput22 req_msg[29] VDD VSS net22 BUFx2_ASAP7_75t_R
Xinput23 req_msg[2] VDD VSS net23 BUFx2_ASAP7_75t_R
Xinput24 req_msg[30] VDD VSS net24 BUFx2_ASAP7_75t_R
Xinput25 req_msg[31] VDD VSS net25 BUFx2_ASAP7_75t_R
Xinput26 req_msg[3] VDD VSS net26 BUFx2_ASAP7_75t_R
Xinput27 req_msg[4] VDD VSS net27 BUFx2_ASAP7_75t_R
Xinput28 req_msg[5] VDD VSS net28 BUFx2_ASAP7_75t_R
Xinput29 req_msg[6] VDD VSS net29 BUFx2_ASAP7_75t_R
Xinput30 req_msg[7] VDD VSS net30 BUFx2_ASAP7_75t_R
Xinput31 req_msg[8] VDD VSS net31 BUFx2_ASAP7_75t_R
Xinput32 req_msg[9] VDD VSS net32 BUFx2_ASAP7_75t_R
Xinput33 req_val VDD VSS net33 BUFx2_ASAP7_75t_R
Xinput34 reset VDD VSS net34 BUFx2_ASAP7_75t_R
Xinput35 resp_rdy VDD VSS net35 BUFx2_ASAP7_75t_R
Xoutput36 net36 VDD VSS req_rdy BUFx2_ASAP7_75t_R
Xoutput37 net37 VDD VSS resp_msg[0] BUFx2_ASAP7_75t_R
Xoutput38 net38 VDD VSS resp_msg[10] BUFx2_ASAP7_75t_R
Xoutput39 net39 VDD VSS resp_msg[11] BUFx2_ASAP7_75t_R
Xoutput40 net40 VDD VSS resp_msg[12] BUFx2_ASAP7_75t_R
Xoutput41 net41 VDD VSS resp_msg[13] BUFx2_ASAP7_75t_R
Xoutput42 net42 VDD VSS resp_msg[14] BUFx2_ASAP7_75t_R
Xoutput43 net43 VDD VSS resp_msg[15] BUFx2_ASAP7_75t_R
Xoutput44 net44 VDD VSS resp_msg[1] BUFx2_ASAP7_75t_R
Xoutput45 net45 VDD VSS resp_msg[2] BUFx2_ASAP7_75t_R
Xoutput46 net46 VDD VSS resp_msg[3] BUFx2_ASAP7_75t_R
Xoutput47 net47 VDD VSS resp_msg[4] BUFx2_ASAP7_75t_R
Xoutput48 net48 VDD VSS resp_msg[5] BUFx2_ASAP7_75t_R
Xoutput49 net49 VDD VSS resp_msg[6] BUFx2_ASAP7_75t_R
Xoutput50 net50 VDD VSS resp_msg[7] BUFx2_ASAP7_75t_R
Xoutput51 net51 VDD VSS resp_msg[8] BUFx2_ASAP7_75t_R
Xoutput52 net52 VDD VSS resp_msg[9] BUFx2_ASAP7_75t_R
Xoutput53 net53 VDD VSS resp_val BUFx2_ASAP7_75t_R
Xplace56 _016_ VDD VSS net56 BUFx3_ASAP7_75t_R
Xplace55 _066_ VDD VSS net55 BUFx3_ASAP7_75t_R
Xclkbuf_0_clk clk VDD VSS clknet_0_clk BUFx4_ASAP7_75t_R
Xclkbuf_2_0__f_clk clknet_0_clk VDD VSS clknet_2_0__leaf_clk
+ BUFx4_ASAP7_75t_R
Xclkbuf_2_1__f_clk clknet_0_clk VDD VSS clknet_2_1__leaf_clk
+ BUFx4_ASAP7_75t_R
Xclkbuf_2_2__f_clk clknet_0_clk VDD VSS clknet_2_2__leaf_clk
+ BUFx4_ASAP7_75t_R
Xclkbuf_2_3__f_clk clknet_0_clk VDD VSS clknet_2_3__leaf_clk
+ BUFx4_ASAP7_75t_R
Xclkload0 clknet_2_0__leaf_clk VDD VSS _unconnected_0 BUFx2_ASAP7_75t_R
Xclkload1 clknet_2_1__leaf_clk VDD VSS _unconnected_1 BUFx12_ASAP7_75t_R
Xclkload2 clknet_2_3__leaf_clk VDD VSS _unconnected_2 BUFx2_ASAP7_75t_R
XFILLER_0_2 VDD VSS DECAPx10_ASAP7_75t_R
XFILLER_0_24 VDD VSS DECAPx10_ASAP7_75t_R
XFILLER_0_46 VDD VSS DECAPx10_ASAP7_75t_R
XFILLER_0_68 VDD VSS DECAPx10_ASAP7_75t_R
XFILLER_0_90 VDD VSS DECAPx10_ASAP7_75t_R
XFILLER_0_112 VDD VSS DECAPx6_ASAP7_75t_R
XFILLER_0_126 VDD VSS DECAPx2_ASAP7_75t_R
XFILLER_0_137 VDD VSS DECAPx4_ASAP7_75t_R
XFILLER_0_152 VDD VSS DECAPx10_ASAP7_75t_R
XFILLER_0_174 VDD VSS DECAPx10_ASAP7_75t_R
XFILLER_0_196 VDD VSS DECAPx10_ASAP7_75t_R
XFILLER_0_218 VDD VSS DECAPx10_ASAP7_75t_R
XFILLER_0_240 VDD VSS DECAPx6_ASAP7_75t_R
XFILLER_0_254 VDD VSS DECAPx1_ASAP7_75t_R
XFILLER_1_2 VDD VSS DECAPx10_ASAP7_75t_R
XFILLER_1_24 VDD VSS DECAPx10_ASAP7_75t_R
XFILLER_1_46 VDD VSS DECAPx10_ASAP7_75t_R
XFILLER_1_68 VDD VSS DECAPx2_ASAP7_75t_R
XFILLER_1_79 VDD VSS DECAPx2_ASAP7_75t_R
XFILLER_1_93 VDD VSS DECAPx1_ASAP7_75t_R
XFILLER_1_108 VDD VSS DECAPx4_ASAP7_75t_R
XFILLER_1_125 VDD VSS DECAPx10_ASAP7_75t_R
XFILLER_1_147 VDD VSS DECAPx4_ASAP7_75t_R
XFILLER_1_162 VDD VSS DECAPx10_ASAP7_75t_R
XFILLER_1_184 VDD VSS DECAPx2_ASAP7_75t_R
XFILLER_1_198 VDD VSS DECAPx10_ASAP7_75t_R
XFILLER_1_220 VDD VSS DECAPx10_ASAP7_75t_R
XFILLER_1_242 VDD VSS DECAPx6_ASAP7_75t_R
XFILLER_2_2 VDD VSS DECAPx10_ASAP7_75t_R
XFILLER_2_24 VDD VSS DECAPx10_ASAP7_75t_R
XFILLER_2_46 VDD VSS DECAPx6_ASAP7_75t_R
XFILLER_2_60 VDD VSS DECAPx1_ASAP7_75t_R
XFILLER_2_69 VDD VSS DECAPx10_ASAP7_75t_R
XFILLER_2_91 VDD VSS DECAPx10_ASAP7_75t_R
XFILLER_2_113 VDD VSS DECAPx1_ASAP7_75t_R
XFILLER_2_156 VDD VSS DECAPx10_ASAP7_75t_R
XFILLER_2_178 VDD VSS DECAPx10_ASAP7_75t_R
XFILLER_2_200 VDD VSS DECAPx10_ASAP7_75t_R
XFILLER_2_222 VDD VSS DECAPx10_ASAP7_75t_R
XFILLER_2_244 VDD VSS DECAPx6_ASAP7_75t_R
XFILLER_3_2 VDD VSS DECAPx10_ASAP7_75t_R
XFILLER_3_24 VDD VSS DECAPx10_ASAP7_75t_R
XFILLER_3_46 VDD VSS DECAPx10_ASAP7_75t_R
XFILLER_3_68 VDD VSS DECAPx10_ASAP7_75t_R
XFILLER_3_90 VDD VSS DECAPx10_ASAP7_75t_R
XFILLER_3_112 VDD VSS DECAPx2_ASAP7_75t_R
XFILLER_3_132 VDD VSS DECAPx4_ASAP7_75t_R
XFILLER_3_166 VDD VSS DECAPx10_ASAP7_75t_R
XFILLER_3_188 VDD VSS DECAPx1_ASAP7_75t_R
XFILLER_3_198 VDD VSS DECAPx10_ASAP7_75t_R
XFILLER_3_220 VDD VSS DECAPx10_ASAP7_75t_R
XFILLER_3_242 VDD VSS DECAPx6_ASAP7_75t_R
XFILLER_4_2 VDD VSS DECAPx10_ASAP7_75t_R
XFILLER_4_24 VDD VSS DECAPx10_ASAP7_75t_R
XFILLER_4_46 VDD VSS DECAPx10_ASAP7_75t_R
XFILLER_4_68 VDD VSS DECAPx10_ASAP7_75t_R
XFILLER_4_90 VDD VSS DECAPx10_ASAP7_75t_R
XFILLER_4_112 VDD VSS DECAPx4_ASAP7_75t_R
XFILLER_4_130 VDD VSS DECAPx6_ASAP7_75t_R
XFILLER_4_152 VDD VSS DECAPx10_ASAP7_75t_R
XFILLER_4_174 VDD VSS DECAPx2_ASAP7_75t_R
XFILLER_4_192 VDD VSS DECAPx10_ASAP7_75t_R
XFILLER_4_214 VDD VSS DECAPx10_ASAP7_75t_R
XFILLER_4_236 VDD VSS DECAPx10_ASAP7_75t_R
XFILLER_5_2 VDD VSS DECAPx10_ASAP7_75t_R
XFILLER_5_24 VDD VSS DECAPx10_ASAP7_75t_R
XFILLER_5_46 VDD VSS DECAPx10_ASAP7_75t_R
XFILLER_5_68 VDD VSS DECAPx10_ASAP7_75t_R
XFILLER_5_90 VDD VSS DECAPx10_ASAP7_75t_R
XFILLER_5_112 VDD VSS DECAPx2_ASAP7_75t_R
XFILLER_5_129 VDD VSS DECAPx4_ASAP7_75t_R
XFILLER_5_159 VDD VSS DECAPx6_ASAP7_75t_R
XFILLER_5_187 VDD VSS DECAPx10_ASAP7_75t_R
XFILLER_5_209 VDD VSS DECAPx10_ASAP7_75t_R
XFILLER_5_231 VDD VSS DECAPx10_ASAP7_75t_R
XFILLER_5_253 VDD VSS DECAPx1_ASAP7_75t_R
XFILLER_6_2 VDD VSS DECAPx10_ASAP7_75t_R
XFILLER_6_24 VDD VSS DECAPx10_ASAP7_75t_R
XFILLER_6_46 VDD VSS DECAPx10_ASAP7_75t_R
XFILLER_6_68 VDD VSS DECAPx10_ASAP7_75t_R
XFILLER_6_90 VDD VSS DECAPx10_ASAP7_75t_R
XFILLER_6_112 VDD VSS DECAPx2_ASAP7_75t_R
XFILLER_6_151 VDD VSS DECAPx2_ASAP7_75t_R
XFILLER_6_166 VDD VSS DECAPx1_ASAP7_75t_R
XFILLER_6_184 VDD VSS DECAPx10_ASAP7_75t_R
XFILLER_6_206 VDD VSS DECAPx10_ASAP7_75t_R
XFILLER_6_228 VDD VSS DECAPx10_ASAP7_75t_R
XFILLER_6_250 VDD VSS DECAPx2_ASAP7_75t_R
XFILLER_7_2 VDD VSS DECAPx10_ASAP7_75t_R
XFILLER_7_24 VDD VSS DECAPx10_ASAP7_75t_R
XFILLER_7_46 VDD VSS DECAPx10_ASAP7_75t_R
XFILLER_7_68 VDD VSS DECAPx10_ASAP7_75t_R
XFILLER_7_90 VDD VSS DECAPx1_ASAP7_75t_R
XFILLER_7_106 VDD VSS DECAPx6_ASAP7_75t_R
XFILLER_7_126 VDD VSS DECAPx10_ASAP7_75t_R
XFILLER_7_148 VDD VSS DECAPx4_ASAP7_75t_R
XFILLER_7_161 VDD VSS DECAPx4_ASAP7_75t_R
XFILLER_7_200 VDD VSS DECAPx10_ASAP7_75t_R
XFILLER_7_222 VDD VSS DECAPx10_ASAP7_75t_R
XFILLER_7_244 VDD VSS DECAPx6_ASAP7_75t_R
XFILLER_8_2 VDD VSS DECAPx10_ASAP7_75t_R
XFILLER_8_24 VDD VSS DECAPx10_ASAP7_75t_R
XFILLER_8_46 VDD VSS DECAPx10_ASAP7_75t_R
XFILLER_8_68 VDD VSS DECAPx10_ASAP7_75t_R
XFILLER_8_125 VDD VSS DECAPx4_ASAP7_75t_R
XFILLER_8_140 VDD VSS DECAPx6_ASAP7_75t_R
XFILLER_8_166 VDD VSS DECAPx2_ASAP7_75t_R
XFILLER_8_178 VDD VSS DECAPx10_ASAP7_75t_R
XFILLER_8_200 VDD VSS DECAPx10_ASAP7_75t_R
XFILLER_8_222 VDD VSS DECAPx10_ASAP7_75t_R
XFILLER_8_244 VDD VSS DECAPx6_ASAP7_75t_R
XFILLER_9_2 VDD VSS DECAPx10_ASAP7_75t_R
XFILLER_9_24 VDD VSS DECAPx10_ASAP7_75t_R
XFILLER_9_46 VDD VSS DECAPx10_ASAP7_75t_R
XFILLER_9_68 VDD VSS DECAPx4_ASAP7_75t_R
XFILLER_9_90 VDD VSS DECAPx2_ASAP7_75t_R
XFILLER_9_102 VDD VSS DECAPx2_ASAP7_75t_R
XFILLER_9_129 VDD VSS DECAPx2_ASAP7_75t_R
XFILLER_9_145 VDD VSS DECAPx4_ASAP7_75t_R
XFILLER_9_172 VDD VSS DECAPx4_ASAP7_75t_R
XFILLER_9_194 VDD VSS DECAPx6_ASAP7_75t_R
XFILLER_9_235 VDD VSS DECAPx10_ASAP7_75t_R
XFILLER_10_2 VDD VSS DECAPx10_ASAP7_75t_R
XFILLER_10_24 VDD VSS DECAPx10_ASAP7_75t_R
XFILLER_10_46 VDD VSS DECAPx6_ASAP7_75t_R
XFILLER_10_74 VDD VSS DECAPx2_ASAP7_75t_R
XFILLER_10_101 VDD VSS DECAPx6_ASAP7_75t_R
XFILLER_10_115 VDD VSS DECAPx1_ASAP7_75t_R
XFILLER_10_127 VDD VSS DECAPx6_ASAP7_75t_R
XFILLER_10_141 VDD VSS DECAPx1_ASAP7_75t_R
XFILLER_10_168 VDD VSS DECAPx10_ASAP7_75t_R
XFILLER_10_190 VDD VSS DECAPx2_ASAP7_75t_R
XFILLER_10_202 VDD VSS DECAPx10_ASAP7_75t_R
XFILLER_10_224 VDD VSS DECAPx10_ASAP7_75t_R
XFILLER_10_246 VDD VSS DECAPx4_ASAP7_75t_R
XFILLER_11_2 VDD VSS DECAPx10_ASAP7_75t_R
XFILLER_11_24 VDD VSS DECAPx10_ASAP7_75t_R
XFILLER_11_46 VDD VSS DECAPx10_ASAP7_75t_R
XFILLER_11_68 VDD VSS DECAPx4_ASAP7_75t_R
XFILLER_11_86 VDD VSS DECAPx10_ASAP7_75t_R
XFILLER_11_108 VDD VSS DECAPx1_ASAP7_75t_R
XFILLER_11_129 VDD VSS DECAPx6_ASAP7_75t_R
XFILLER_11_159 VDD VSS DECAPx6_ASAP7_75t_R
XFILLER_11_173 VDD VSS DECAPx2_ASAP7_75t_R
XFILLER_11_187 VDD VSS DECAPx2_ASAP7_75t_R
XFILLER_11_220 VDD VSS DECAPx10_ASAP7_75t_R
XFILLER_11_242 VDD VSS DECAPx6_ASAP7_75t_R
XFILLER_12_2 VDD VSS DECAPx10_ASAP7_75t_R
XFILLER_12_24 VDD VSS DECAPx10_ASAP7_75t_R
XFILLER_12_46 VDD VSS DECAPx6_ASAP7_75t_R
XFILLER_12_88 VDD VSS DECAPx10_ASAP7_75t_R
XFILLER_12_110 VDD VSS DECAPx2_ASAP7_75t_R
XFILLER_12_132 VDD VSS DECAPx2_ASAP7_75t_R
XFILLER_12_147 VDD VSS DECAPx4_ASAP7_75t_R
XFILLER_12_167 VDD VSS DECAPx10_ASAP7_75t_R
XFILLER_12_232 VDD VSS DECAPx1_ASAP7_75t_R
XFILLER_12_242 VDD VSS DECAPx6_ASAP7_75t_R
XFILLER_13_2 VDD VSS DECAPx10_ASAP7_75t_R
XFILLER_13_24 VDD VSS DECAPx10_ASAP7_75t_R
XFILLER_13_46 VDD VSS DECAPx6_ASAP7_75t_R
XFILLER_13_60 VDD VSS DECAPx2_ASAP7_75t_R
XFILLER_13_70 VDD VSS DECAPx2_ASAP7_75t_R
XFILLER_13_86 VDD VSS DECAPx10_ASAP7_75t_R
XFILLER_13_108 VDD VSS DECAPx10_ASAP7_75t_R
XFILLER_13_130 VDD VSS DECAPx4_ASAP7_75t_R
XFILLER_13_178 VDD VSS DECAPx10_ASAP7_75t_R
XFILLER_13_200 VDD VSS DECAPx2_ASAP7_75t_R
XFILLER_13_213 VDD VSS DECAPx10_ASAP7_75t_R
XFILLER_13_235 VDD VSS DECAPx10_ASAP7_75t_R
XFILLER_14_2 VDD VSS DECAPx10_ASAP7_75t_R
XFILLER_14_24 VDD VSS DECAPx10_ASAP7_75t_R
XFILLER_14_46 VDD VSS DECAPx6_ASAP7_75t_R
XFILLER_14_67 VDD VSS DECAPx4_ASAP7_75t_R
XFILLER_14_80 VDD VSS DECAPx10_ASAP7_75t_R
XFILLER_14_102 VDD VSS DECAPx10_ASAP7_75t_R
XFILLER_14_124 VDD VSS DECAPx10_ASAP7_75t_R
XFILLER_14_146 VDD VSS DECAPx6_ASAP7_75t_R
XFILLER_14_160 VDD VSS DECAPx1_ASAP7_75t_R
XFILLER_14_193 VDD VSS DECAPx10_ASAP7_75t_R
XFILLER_14_215 VDD VSS DECAPx10_ASAP7_75t_R
XFILLER_14_237 VDD VSS DECAPx6_ASAP7_75t_R
XFILLER_14_251 VDD VSS DECAPx2_ASAP7_75t_R
XFILLER_15_2 VDD VSS DECAPx10_ASAP7_75t_R
XFILLER_15_24 VDD VSS DECAPx10_ASAP7_75t_R
XFILLER_15_46 VDD VSS DECAPx4_ASAP7_75t_R
XFILLER_15_85 VDD VSS DECAPx1_ASAP7_75t_R
XFILLER_15_110 VDD VSS DECAPx4_ASAP7_75t_R
XFILLER_15_138 VDD VSS DECAPx10_ASAP7_75t_R
XFILLER_15_160 VDD VSS DECAPx4_ASAP7_75t_R
XFILLER_15_188 VDD VSS DECAPx10_ASAP7_75t_R
XFILLER_15_210 VDD VSS DECAPx10_ASAP7_75t_R
XFILLER_15_232 VDD VSS DECAPx10_ASAP7_75t_R
XFILLER_15_254 VDD VSS DECAPx1_ASAP7_75t_R
XFILLER_16_2 VDD VSS DECAPx10_ASAP7_75t_R
XFILLER_16_24 VDD VSS DECAPx10_ASAP7_75t_R
XFILLER_16_46 VDD VSS DECAPx6_ASAP7_75t_R
XFILLER_16_82 VDD VSS DECAPx2_ASAP7_75t_R
XFILLER_16_144 VDD VSS DECAPx6_ASAP7_75t_R
XFILLER_16_158 VDD VSS DECAPx2_ASAP7_75t_R
XFILLER_16_171 VDD VSS DECAPx6_ASAP7_75t_R
XFILLER_16_203 VDD VSS DECAPx10_ASAP7_75t_R
XFILLER_16_225 VDD VSS DECAPx10_ASAP7_75t_R
XFILLER_16_247 VDD VSS DECAPx4_ASAP7_75t_R
XFILLER_17_2 VDD VSS DECAPx10_ASAP7_75t_R
XFILLER_17_24 VDD VSS DECAPx10_ASAP7_75t_R
XFILLER_17_46 VDD VSS DECAPx10_ASAP7_75t_R
XFILLER_17_68 VDD VSS DECAPx1_ASAP7_75t_R
XFILLER_17_80 VDD VSS DECAPx4_ASAP7_75t_R
XFILLER_17_99 VDD VSS DECAPx4_ASAP7_75t_R
XFILLER_17_125 VDD VSS DECAPx4_ASAP7_75t_R
XFILLER_17_173 VDD VSS DECAPx6_ASAP7_75t_R
XFILLER_17_196 VDD VSS DECAPx10_ASAP7_75t_R
XFILLER_17_218 VDD VSS DECAPx10_ASAP7_75t_R
XFILLER_17_240 VDD VSS DECAPx6_ASAP7_75t_R
XFILLER_17_254 VDD VSS DECAPx1_ASAP7_75t_R
XFILLER_18_2 VDD VSS DECAPx6_ASAP7_75t_R
XFILLER_18_16 VDD VSS DECAPx2_ASAP7_75t_R
XFILLER_18_27 VDD VSS DECAPx10_ASAP7_75t_R
XFILLER_18_49 VDD VSS DECAPx10_ASAP7_75t_R
XFILLER_18_71 VDD VSS DECAPx2_ASAP7_75t_R
XFILLER_18_84 VDD VSS DECAPx10_ASAP7_75t_R
XFILLER_18_106 VDD VSS DECAPx10_ASAP7_75t_R
XFILLER_18_128 VDD VSS DECAPx4_ASAP7_75t_R
XFILLER_18_158 VDD VSS DECAPx2_ASAP7_75t_R
XFILLER_18_207 VDD VSS DECAPx10_ASAP7_75t_R
XFILLER_18_229 VDD VSS DECAPx10_ASAP7_75t_R
XFILLER_18_251 VDD VSS DECAPx2_ASAP7_75t_R
XFILLER_19_2 VDD VSS DECAPx10_ASAP7_75t_R
XFILLER_19_24 VDD VSS DECAPx2_ASAP7_75t_R
XFILLER_19_38 VDD VSS DECAPx6_ASAP7_75t_R
XFILLER_19_64 VDD VSS DECAPx10_ASAP7_75t_R
XFILLER_19_86 VDD VSS DECAPx4_ASAP7_75t_R
XFILLER_19_119 VDD VSS DECAPx6_ASAP7_75t_R
XFILLER_19_133 VDD VSS DECAPx2_ASAP7_75t_R
XFILLER_19_145 VDD VSS DECAPx6_ASAP7_75t_R
XFILLER_19_159 VDD VSS DECAPx2_ASAP7_75t_R
XFILLER_19_173 VDD VSS DECAPx6_ASAP7_75t_R
XFILLER_19_215 VDD VSS DECAPx10_ASAP7_75t_R
XFILLER_19_237 VDD VSS DECAPx6_ASAP7_75t_R
XFILLER_19_251 VDD VSS DECAPx2_ASAP7_75t_R
XFILLER_20_2 VDD VSS DECAPx10_ASAP7_75t_R
XFILLER_20_24 VDD VSS DECAPx1_ASAP7_75t_R
XFILLER_20_65 VDD VSS DECAPx10_ASAP7_75t_R
XFILLER_20_87 VDD VSS DECAPx10_ASAP7_75t_R
XFILLER_20_109 VDD VSS DECAPx10_ASAP7_75t_R
XFILLER_20_138 VDD VSS DECAPx10_ASAP7_75t_R
XFILLER_20_160 VDD VSS DECAPx2_ASAP7_75t_R
XFILLER_20_175 VDD VSS DECAPx6_ASAP7_75t_R
XFILLER_20_203 VDD VSS DECAPx10_ASAP7_75t_R
XFILLER_20_225 VDD VSS DECAPx10_ASAP7_75t_R
XFILLER_20_247 VDD VSS DECAPx4_ASAP7_75t_R
XFILLER_21_33 VDD VSS DECAPx1_ASAP7_75t_R
XFILLER_21_51 VDD VSS DECAPx2_ASAP7_75t_R
XFILLER_21_74 VDD VSS DECAPx1_ASAP7_75t_R
XFILLER_21_141 VDD VSS DECAPx10_ASAP7_75t_R
XFILLER_21_163 VDD VSS DECAPx1_ASAP7_75t_R
XFILLER_21_183 VDD VSS DECAPx2_ASAP7_75t_R
XFILLER_21_213 VDD VSS DECAPx4_ASAP7_75t_R
XFILLER_21_228 VDD VSS DECAPx10_ASAP7_75t_R
XFILLER_21_250 VDD VSS DECAPx2_ASAP7_75t_R
XFILLER_22_2 VDD VSS DECAPx2_ASAP7_75t_R
XFILLER_22_21 VDD VSS DECAPx1_ASAP7_75t_R
XFILLER_22_99 VDD VSS DECAPx1_ASAP7_75t_R
XFILLER_22_117 VDD VSS DECAPx10_ASAP7_75t_R
XFILLER_22_139 VDD VSS DECAPx10_ASAP7_75t_R
XFILLER_22_161 VDD VSS DECAPx10_ASAP7_75t_R
XFILLER_22_183 VDD VSS DECAPx2_ASAP7_75t_R
XFILLER_22_214 VDD VSS DECAPx10_ASAP7_75t_R
XFILLER_22_241 VDD VSS DECAPx6_ASAP7_75t_R
XFILLER_23_2 VDD VSS DECAPx10_ASAP7_75t_R
XFILLER_23_24 VDD VSS DECAPx10_ASAP7_75t_R
XFILLER_23_52 VDD VSS DECAPx2_ASAP7_75t_R
XFILLER_23_70 VDD VSS DECAPx2_ASAP7_75t_R
XFILLER_23_99 VDD VSS DECAPx2_ASAP7_75t_R
XFILLER_23_128 VDD VSS DECAPx10_ASAP7_75t_R
XFILLER_23_150 VDD VSS DECAPx6_ASAP7_75t_R
XFILLER_23_171 VDD VSS DECAPx6_ASAP7_75t_R
XFILLER_23_201 VDD VSS DECAPx10_ASAP7_75t_R
XFILLER_23_223 VDD VSS DECAPx10_ASAP7_75t_R
XFILLER_23_245 VDD VSS DECAPx4_ASAP7_75t_R
XFILLER_24_2 VDD VSS DECAPx10_ASAP7_75t_R
XFILLER_24_24 VDD VSS DECAPx10_ASAP7_75t_R
XFILLER_24_46 VDD VSS DECAPx10_ASAP7_75t_R
XFILLER_24_68 VDD VSS DECAPx10_ASAP7_75t_R
XFILLER_24_90 VDD VSS DECAPx4_ASAP7_75t_R
XFILLER_24_108 VDD VSS DECAPx10_ASAP7_75t_R
XFILLER_24_130 VDD VSS DECAPx10_ASAP7_75t_R
XFILLER_24_180 VDD VSS DECAPx2_ASAP7_75t_R
XFILLER_24_193 VDD VSS DECAPx1_ASAP7_75t_R
XFILLER_24_203 VDD VSS DECAPx10_ASAP7_75t_R
XFILLER_24_225 VDD VSS DECAPx10_ASAP7_75t_R
XFILLER_24_247 VDD VSS DECAPx4_ASAP7_75t_R
XFILLER_25_2 VDD VSS DECAPx10_ASAP7_75t_R
XFILLER_25_24 VDD VSS DECAPx10_ASAP7_75t_R
XFILLER_25_46 VDD VSS DECAPx10_ASAP7_75t_R
XFILLER_25_68 VDD VSS DECAPx10_ASAP7_75t_R
XFILLER_25_96 VDD VSS DECAPx10_ASAP7_75t_R
XFILLER_25_118 VDD VSS DECAPx4_ASAP7_75t_R
XFILLER_25_137 VDD VSS DECAPx4_ASAP7_75t_R
XFILLER_25_170 VDD VSS DECAPx10_ASAP7_75t_R
XFILLER_25_210 VDD VSS DECAPx10_ASAP7_75t_R
XFILLER_25_232 VDD VSS DECAPx10_ASAP7_75t_R
XFILLER_25_254 VDD VSS DECAPx1_ASAP7_75t_R
XFILLER_26_2 VDD VSS DECAPx4_ASAP7_75t_R
XFILLER_26_20 VDD VSS DECAPx10_ASAP7_75t_R
XFILLER_26_50 VDD VSS DECAPx10_ASAP7_75t_R
XFILLER_26_72 VDD VSS DECAPx4_ASAP7_75t_R
XFILLER_26_102 VDD VSS DECAPx10_ASAP7_75t_R
XFILLER_26_124 VDD VSS DECAPx10_ASAP7_75t_R
XFILLER_26_146 VDD VSS DECAPx6_ASAP7_75t_R
XFILLER_26_160 VDD VSS DECAPx1_ASAP7_75t_R
XFILLER_26_175 VDD VSS DECAPx4_ASAP7_75t_R
XFILLER_26_195 VDD VSS DECAPx10_ASAP7_75t_R
XFILLER_26_217 VDD VSS DECAPx2_ASAP7_75t_R
XFILLER_26_230 VDD VSS DECAPx10_ASAP7_75t_R
XFILLER_26_252 VDD VSS DECAPx2_ASAP7_75t_R
XFILLER_27_2 VDD VSS DECAPx10_ASAP7_75t_R
XFILLER_27_29 VDD VSS DECAPx6_ASAP7_75t_R
XFILLER_27_64 VDD VSS DECAPx10_ASAP7_75t_R
XFILLER_27_86 VDD VSS DECAPx1_ASAP7_75t_R
XFILLER_27_99 VDD VSS DECAPx2_ASAP7_75t_R
XFILLER_27_160 VDD VSS DECAPx1_ASAP7_75t_R
XFILLER_27_177 VDD VSS DECAPx2_ASAP7_75t_R
XFILLER_27_191 VDD VSS DECAPx10_ASAP7_75t_R
XFILLER_27_213 VDD VSS DECAPx10_ASAP7_75t_R
XFILLER_27_235 VDD VSS DECAPx10_ASAP7_75t_R
XFILLER_28_2 VDD VSS DECAPx10_ASAP7_75t_R
XFILLER_28_24 VDD VSS DECAPx2_ASAP7_75t_R
XFILLER_28_64 VDD VSS DECAPx2_ASAP7_75t_R
XFILLER_28_83 VDD VSS DECAPx6_ASAP7_75t_R
XFILLER_28_97 VDD VSS DECAPx2_ASAP7_75t_R
XFILLER_28_154 VDD VSS DECAPx1_ASAP7_75t_R
XFILLER_28_162 VDD VSS DECAPx2_ASAP7_75t_R
XFILLER_28_183 VDD VSS DECAPx2_ASAP7_75t_R
XFILLER_28_206 VDD VSS DECAPx10_ASAP7_75t_R
XFILLER_28_234 VDD VSS DECAPx10_ASAP7_75t_R
XFILLER_29_2 VDD VSS DECAPx10_ASAP7_75t_R
XFILLER_29_24 VDD VSS DECAPx10_ASAP7_75t_R
XFILLER_29_46 VDD VSS DECAPx4_ASAP7_75t_R
XFILLER_29_78 VDD VSS DECAPx10_ASAP7_75t_R
XFILLER_29_106 VDD VSS DECAPx10_ASAP7_75t_R
XFILLER_29_135 VDD VSS DECAPx1_ASAP7_75t_R
XFILLER_29_166 VDD VSS DECAPx6_ASAP7_75t_R
XFILLER_29_197 VDD VSS DECAPx10_ASAP7_75t_R
XFILLER_29_226 VDD VSS DECAPx10_ASAP7_75t_R
XFILLER_29_248 VDD VSS DECAPx4_ASAP7_75t_R
XFILLER_30_2 VDD VSS DECAPx2_ASAP7_75t_R
XFILLER_30_13 VDD VSS DECAPx10_ASAP7_75t_R
XFILLER_30_35 VDD VSS DECAPx10_ASAP7_75t_R
XFILLER_30_57 VDD VSS DECAPx4_ASAP7_75t_R
XFILLER_30_87 VDD VSS DECAPx1_ASAP7_75t_R
XFILLER_30_114 VDD VSS DECAPx10_ASAP7_75t_R
XFILLER_30_136 VDD VSS DECAPx10_ASAP7_75t_R
XFILLER_30_158 VDD VSS DECAPx10_ASAP7_75t_R
XFILLER_30_180 VDD VSS DECAPx10_ASAP7_75t_R
XFILLER_30_202 VDD VSS DECAPx10_ASAP7_75t_R
XFILLER_30_224 VDD VSS DECAPx10_ASAP7_75t_R
XFILLER_30_246 VDD VSS DECAPx4_ASAP7_75t_R
XFILLER_31_2 VDD VSS DECAPx10_ASAP7_75t_R
XFILLER_31_24 VDD VSS DECAPx10_ASAP7_75t_R
XFILLER_31_46 VDD VSS DECAPx10_ASAP7_75t_R
XFILLER_31_68 VDD VSS DECAPx10_ASAP7_75t_R
XFILLER_31_90 VDD VSS DECAPx1_ASAP7_75t_R
XFILLER_31_101 VDD VSS DECAPx10_ASAP7_75t_R
XFILLER_31_123 VDD VSS DECAPx1_ASAP7_75t_R
XFILLER_31_130 VDD VSS DECAPx10_ASAP7_75t_R
XFILLER_31_152 VDD VSS DECAPx10_ASAP7_75t_R
XFILLER_31_174 VDD VSS DECAPx10_ASAP7_75t_R
XFILLER_31_196 VDD VSS DECAPx10_ASAP7_75t_R
XFILLER_31_218 VDD VSS DECAPx10_ASAP7_75t_R
XFILLER_31_240 VDD VSS DECAPx6_ASAP7_75t_R
XFILLER_31_254 VDD VSS DECAPx1_ASAP7_75t_R
XFILLER_32_2 VDD VSS DECAPx10_ASAP7_75t_R
XFILLER_32_24 VDD VSS DECAPx10_ASAP7_75t_R
XFILLER_32_46 VDD VSS DECAPx10_ASAP7_75t_R
XFILLER_32_68 VDD VSS DECAPx10_ASAP7_75t_R
XFILLER_32_90 VDD VSS DECAPx6_ASAP7_75t_R
XFILLER_32_113 VDD VSS DECAPx10_ASAP7_75t_R
XFILLER_32_135 VDD VSS DECAPx10_ASAP7_75t_R
XFILLER_32_157 VDD VSS DECAPx1_ASAP7_75t_R
XFILLER_32_169 VDD VSS DECAPx10_ASAP7_75t_R
XFILLER_32_191 VDD VSS DECAPx10_ASAP7_75t_R
XFILLER_32_213 VDD VSS DECAPx10_ASAP7_75t_R
XFILLER_32_235 VDD VSS DECAPx10_ASAP7_75t_R
XFILLER_33_2 VDD VSS DECAPx10_ASAP7_75t_R
XFILLER_33_24 VDD VSS DECAPx6_ASAP7_75t_R
XFILLER_33_38 VDD VSS DECAPx2_ASAP7_75t_R
XFILLER_33_52 VDD VSS DECAPx10_ASAP7_75t_R
XFILLER_33_74 VDD VSS DECAPx10_ASAP7_75t_R
XFILLER_33_96 VDD VSS DECAPx10_ASAP7_75t_R
XFILLER_33_118 VDD VSS DECAPx2_ASAP7_75t_R
XFILLER_33_146 VDD VSS DECAPx4_ASAP7_75t_R
XFILLER_33_173 VDD VSS DECAPx2_ASAP7_75t_R
XFILLER_33_205 VDD VSS DECAPx10_ASAP7_75t_R
XFILLER_33_227 VDD VSS DECAPx10_ASAP7_75t_R
XFILLER_33_249 VDD VSS DECAPx2_ASAP7_75t_R
XFILLER_34_7 VDD VSS DECAPx4_ASAP7_75t_R
XFILLER_34_24 VDD VSS DECAPx6_ASAP7_75t_R
XFILLER_34_38 VDD VSS DECAPx2_ASAP7_75t_R
XFILLER_34_74 VDD VSS DECAPx2_ASAP7_75t_R
XFILLER_34_88 VDD VSS DECAPx2_ASAP7_75t_R
XFILLER_34_106 VDD VSS DECAPx4_ASAP7_75t_R
XFILLER_34_137 VDD VSS DECAPx1_ASAP7_75t_R
XFILLER_34_164 VDD VSS DECAPx4_ASAP7_75t_R
XFILLER_34_187 VDD VSS DECAPx10_ASAP7_75t_R
XFILLER_34_209 VDD VSS DECAPx6_ASAP7_75t_R
XFILLER_34_229 VDD VSS DECAPx10_ASAP7_75t_R
XFILLER_34_251 VDD VSS DECAPx2_ASAP7_75t_R
XFILLER_35_2 VDD VSS DECAPx10_ASAP7_75t_R
XFILLER_35_24 VDD VSS DECAPx6_ASAP7_75t_R
XFILLER_35_55 VDD VSS DECAPx2_ASAP7_75t_R
XFILLER_35_147 VDD VSS DECAPx6_ASAP7_75t_R
XFILLER_35_196 VDD VSS DECAPx10_ASAP7_75t_R
XFILLER_35_218 VDD VSS DECAPx10_ASAP7_75t_R
XFILLER_35_240 VDD VSS DECAPx6_ASAP7_75t_R
XFILLER_35_254 VDD VSS DECAPx1_ASAP7_75t_R
XFILLER_36_2 VDD VSS DECAPx10_ASAP7_75t_R
XFILLER_36_24 VDD VSS DECAPx6_ASAP7_75t_R
XFILLER_36_67 VDD VSS DECAPx10_ASAP7_75t_R
XFILLER_36_89 VDD VSS DECAPx2_ASAP7_75t_R
XFILLER_36_106 VDD VSS DECAPx6_ASAP7_75t_R
XFILLER_36_128 VDD VSS DECAPx6_ASAP7_75t_R
XFILLER_36_142 VDD VSS DECAPx2_ASAP7_75t_R
XFILLER_36_155 VDD VSS DECAPx2_ASAP7_75t_R
XFILLER_36_169 VDD VSS DECAPx2_ASAP7_75t_R
XFILLER_36_194 VDD VSS DECAPx10_ASAP7_75t_R
XFILLER_36_216 VDD VSS DECAPx10_ASAP7_75t_R
XFILLER_36_238 VDD VSS DECAPx6_ASAP7_75t_R
XFILLER_36_252 VDD VSS DECAPx2_ASAP7_75t_R
XFILLER_37_2 VDD VSS DECAPx10_ASAP7_75t_R
XFILLER_37_24 VDD VSS DECAPx10_ASAP7_75t_R
XFILLER_37_46 VDD VSS DECAPx2_ASAP7_75t_R
XFILLER_37_63 VDD VSS DECAPx10_ASAP7_75t_R
XFILLER_37_85 VDD VSS DECAPx10_ASAP7_75t_R
XFILLER_37_107 VDD VSS DECAPx6_ASAP7_75t_R
XFILLER_37_121 VDD VSS DECAPx2_ASAP7_75t_R
XFILLER_37_139 VDD VSS DECAPx10_ASAP7_75t_R
XFILLER_37_161 VDD VSS DECAPx6_ASAP7_75t_R
XFILLER_37_183 VDD VSS DECAPx10_ASAP7_75t_R
XFILLER_37_205 VDD VSS DECAPx10_ASAP7_75t_R
XFILLER_37_227 VDD VSS DECAPx10_ASAP7_75t_R
XFILLER_37_249 VDD VSS DECAPx2_ASAP7_75t_R
XFILLER_38_2 VDD VSS DECAPx10_ASAP7_75t_R
XFILLER_38_24 VDD VSS DECAPx10_ASAP7_75t_R
XFILLER_38_46 VDD VSS DECAPx10_ASAP7_75t_R
XFILLER_38_68 VDD VSS DECAPx10_ASAP7_75t_R
XFILLER_38_96 VDD VSS DECAPx10_ASAP7_75t_R
XFILLER_38_118 VDD VSS DECAPx6_ASAP7_75t_R
XFILLER_38_141 VDD VSS DECAPx2_ASAP7_75t_R
XFILLER_38_155 VDD VSS DECAPx10_ASAP7_75t_R
XFILLER_38_177 VDD VSS DECAPx10_ASAP7_75t_R
XFILLER_38_199 VDD VSS DECAPx10_ASAP7_75t_R
XFILLER_38_221 VDD VSS DECAPx10_ASAP7_75t_R
XFILLER_38_243 VDD VSS DECAPx6_ASAP7_75t_R
XFILLER_39_2 VDD VSS DECAPx10_ASAP7_75t_R
XFILLER_39_24 VDD VSS DECAPx10_ASAP7_75t_R
XFILLER_39_46 VDD VSS DECAPx6_ASAP7_75t_R
XFILLER_39_63 VDD VSS DECAPx10_ASAP7_75t_R
XFILLER_39_85 VDD VSS DECAPx2_ASAP7_75t_R
XFILLER_39_97 VDD VSS DECAPx6_ASAP7_75t_R
XFILLER_39_122 VDD VSS DECAPx1_ASAP7_75t_R
XFILLER_39_136 VDD VSS DECAPx10_ASAP7_75t_R
XFILLER_39_158 VDD VSS DECAPx4_ASAP7_75t_R
XFILLER_39_187 VDD VSS DECAPx10_ASAP7_75t_R
XFILLER_39_209 VDD VSS DECAPx10_ASAP7_75t_R
XFILLER_39_231 VDD VSS DECAPx10_ASAP7_75t_R
XFILLER_39_253 VDD VSS DECAPx1_ASAP7_75t_R
XFILLER_40_2 VDD VSS DECAPx10_ASAP7_75t_R
XFILLER_40_24 VDD VSS DECAPx10_ASAP7_75t_R
XFILLER_40_64 VDD VSS DECAPx1_ASAP7_75t_R
XFILLER_40_74 VDD VSS DECAPx4_ASAP7_75t_R
XFILLER_40_102 VDD VSS DECAPx10_ASAP7_75t_R
XFILLER_40_146 VDD VSS DECAPx6_ASAP7_75t_R
XFILLER_40_180 VDD VSS DECAPx10_ASAP7_75t_R
XFILLER_40_202 VDD VSS DECAPx10_ASAP7_75t_R
XFILLER_40_224 VDD VSS DECAPx10_ASAP7_75t_R
XFILLER_40_246 VDD VSS DECAPx4_ASAP7_75t_R
XFILLER_41_2 VDD VSS DECAPx10_ASAP7_75t_R
XFILLER_41_24 VDD VSS DECAPx10_ASAP7_75t_R
XFILLER_41_74 VDD VSS DECAPx4_ASAP7_75t_R
XFILLER_41_97 VDD VSS DECAPx10_ASAP7_75t_R
XFILLER_41_119 VDD VSS DECAPx1_ASAP7_75t_R
XFILLER_41_131 VDD VSS DECAPx1_ASAP7_75t_R
XFILLER_41_149 VDD VSS DECAPx4_ASAP7_75t_R
XFILLER_41_169 VDD VSS DECAPx1_ASAP7_75t_R
XFILLER_41_180 VDD VSS DECAPx10_ASAP7_75t_R
XFILLER_41_202 VDD VSS DECAPx10_ASAP7_75t_R
XFILLER_41_224 VDD VSS DECAPx10_ASAP7_75t_R
XFILLER_41_246 VDD VSS DECAPx4_ASAP7_75t_R
XFILLER_42_2 VDD VSS DECAPx10_ASAP7_75t_R
XFILLER_42_24 VDD VSS DECAPx6_ASAP7_75t_R
XFILLER_42_38 VDD VSS DECAPx2_ASAP7_75t_R
XFILLER_42_74 VDD VSS DECAPx1_ASAP7_75t_R
XFILLER_42_108 VDD VSS DECAPx2_ASAP7_75t_R
XFILLER_42_129 VDD VSS DECAPx6_ASAP7_75t_R
XFILLER_42_169 VDD VSS DECAPx1_ASAP7_75t_R
XFILLER_42_184 VDD VSS DECAPx10_ASAP7_75t_R
XFILLER_42_206 VDD VSS DECAPx10_ASAP7_75t_R
XFILLER_42_228 VDD VSS DECAPx10_ASAP7_75t_R
XFILLER_42_250 VDD VSS DECAPx2_ASAP7_75t_R
XFILLER_43_2 VDD VSS DECAPx10_ASAP7_75t_R
XFILLER_43_24 VDD VSS DECAPx10_ASAP7_75t_R
XFILLER_43_46 VDD VSS DECAPx10_ASAP7_75t_R
XFILLER_43_78 VDD VSS DECAPx6_ASAP7_75t_R
XFILLER_43_102 VDD VSS DECAPx10_ASAP7_75t_R
XFILLER_43_124 VDD VSS DECAPx10_ASAP7_75t_R
XFILLER_43_146 VDD VSS DECAPx6_ASAP7_75t_R
XFILLER_43_160 VDD VSS DECAPx2_ASAP7_75t_R
XFILLER_43_176 VDD VSS DECAPx10_ASAP7_75t_R
XFILLER_43_198 VDD VSS DECAPx10_ASAP7_75t_R
XFILLER_43_220 VDD VSS DECAPx10_ASAP7_75t_R
XFILLER_43_242 VDD VSS DECAPx6_ASAP7_75t_R
XFILLER_44_2 VDD VSS DECAPx10_ASAP7_75t_R
XFILLER_44_24 VDD VSS DECAPx10_ASAP7_75t_R
XFILLER_44_46 VDD VSS DECAPx4_ASAP7_75t_R
XFILLER_44_75 VDD VSS DECAPx6_ASAP7_75t_R
XFILLER_44_89 VDD VSS DECAPx1_ASAP7_75t_R
XFILLER_44_99 VDD VSS DECAPx6_ASAP7_75t_R
XFILLER_44_113 VDD VSS DECAPx1_ASAP7_75t_R
XFILLER_44_124 VDD VSS DECAPx6_ASAP7_75t_R
XFILLER_44_167 VDD VSS DECAPx10_ASAP7_75t_R
XFILLER_44_189 VDD VSS DECAPx10_ASAP7_75t_R
XFILLER_44_211 VDD VSS DECAPx10_ASAP7_75t_R
XFILLER_44_233 VDD VSS DECAPx10_ASAP7_75t_R
XFILLER_45_2 VDD VSS DECAPx10_ASAP7_75t_R
XFILLER_45_24 VDD VSS DECAPx10_ASAP7_75t_R
XFILLER_45_46 VDD VSS DECAPx6_ASAP7_75t_R
XFILLER_45_83 VDD VSS DECAPx2_ASAP7_75t_R
XFILLER_45_98 VDD VSS DECAPx6_ASAP7_75t_R
XFILLER_45_151 VDD VSS DECAPx10_ASAP7_75t_R
XFILLER_45_173 VDD VSS DECAPx10_ASAP7_75t_R
XFILLER_45_195 VDD VSS DECAPx10_ASAP7_75t_R
XFILLER_45_217 VDD VSS DECAPx10_ASAP7_75t_R
XFILLER_45_239 VDD VSS DECAPx6_ASAP7_75t_R
XFILLER_45_253 VDD VSS DECAPx1_ASAP7_75t_R
XFILLER_46_2 VDD VSS DECAPx10_ASAP7_75t_R
XFILLER_46_24 VDD VSS DECAPx10_ASAP7_75t_R
XFILLER_46_46 VDD VSS DECAPx10_ASAP7_75t_R
XFILLER_46_68 VDD VSS DECAPx10_ASAP7_75t_R
XFILLER_46_110 VDD VSS DECAPx2_ASAP7_75t_R
XFILLER_46_126 VDD VSS DECAPx1_ASAP7_75t_R
XFILLER_46_150 VDD VSS DECAPx10_ASAP7_75t_R
XFILLER_46_172 VDD VSS DECAPx10_ASAP7_75t_R
XFILLER_46_194 VDD VSS DECAPx10_ASAP7_75t_R
XFILLER_46_216 VDD VSS DECAPx10_ASAP7_75t_R
XFILLER_46_238 VDD VSS DECAPx6_ASAP7_75t_R
XFILLER_46_252 VDD VSS DECAPx2_ASAP7_75t_R
XFILLER_47_2 VDD VSS DECAPx10_ASAP7_75t_R
XFILLER_47_24 VDD VSS DECAPx10_ASAP7_75t_R
XFILLER_47_46 VDD VSS DECAPx10_ASAP7_75t_R
XFILLER_47_68 VDD VSS DECAPx6_ASAP7_75t_R
XFILLER_47_82 VDD VSS DECAPx2_ASAP7_75t_R
XFILLER_47_118 VDD VSS DECAPx10_ASAP7_75t_R
XFILLER_47_140 VDD VSS DECAPx10_ASAP7_75t_R
XFILLER_47_162 VDD VSS DECAPx10_ASAP7_75t_R
XFILLER_47_184 VDD VSS DECAPx10_ASAP7_75t_R
XFILLER_47_206 VDD VSS DECAPx10_ASAP7_75t_R
XFILLER_47_228 VDD VSS DECAPx10_ASAP7_75t_R
XFILLER_47_250 VDD VSS DECAPx2_ASAP7_75t_R
XFILLER_48_2 VDD VSS DECAPx10_ASAP7_75t_R
XFILLER_48_24 VDD VSS DECAPx10_ASAP7_75t_R
XFILLER_48_46 VDD VSS DECAPx10_ASAP7_75t_R
XFILLER_48_68 VDD VSS DECAPx6_ASAP7_75t_R
XFILLER_48_82 VDD VSS DECAPx1_ASAP7_75t_R
XFILLER_48_99 VDD VSS DECAPx1_ASAP7_75t_R
XFILLER_48_109 VDD VSS DECAPx10_ASAP7_75t_R
XFILLER_48_131 VDD VSS DECAPx4_ASAP7_75t_R
XFILLER_48_154 VDD VSS DECAPx6_ASAP7_75t_R
XFILLER_48_168 VDD VSS DECAPx2_ASAP7_75t_R
XFILLER_48_187 VDD VSS DECAPx10_ASAP7_75t_R
XFILLER_48_209 VDD VSS DECAPx10_ASAP7_75t_R
XFILLER_48_231 VDD VSS DECAPx10_ASAP7_75t_R
XFILLER_48_253 VDD VSS DECAPx1_ASAP7_75t_R
XFILLER_49_2 VDD VSS DECAPx10_ASAP7_75t_R
XFILLER_49_24 VDD VSS DECAPx6_ASAP7_75t_R
XFILLER_49_38 VDD VSS DECAPx2_ASAP7_75t_R
XFILLER_49_49 VDD VSS DECAPx2_ASAP7_75t_R
XFILLER_49_69 VDD VSS DECAPx6_ASAP7_75t_R
XFILLER_49_83 VDD VSS DECAPx2_ASAP7_75t_R
XFILLER_49_94 VDD VSS DECAPx4_ASAP7_75t_R
XFILLER_49_111 VDD VSS DECAPx2_ASAP7_75t_R
XFILLER_49_135 VDD VSS DECAPx10_ASAP7_75t_R
XFILLER_49_157 VDD VSS DECAPx10_ASAP7_75t_R
XFILLER_49_179 VDD VSS DECAPx10_ASAP7_75t_R
XFILLER_49_201 VDD VSS DECAPx10_ASAP7_75t_R
XFILLER_49_223 VDD VSS DECAPx10_ASAP7_75t_R
XFILLER_49_245 VDD VSS DECAPx4_ASAP7_75t_R
XFILLER_50_2 VDD VSS DECAPx10_ASAP7_75t_R
XFILLER_50_24 VDD VSS DECAPx10_ASAP7_75t_R
XFILLER_50_46 VDD VSS DECAPx10_ASAP7_75t_R
XFILLER_50_68 VDD VSS DECAPx10_ASAP7_75t_R
XFILLER_50_90 VDD VSS DECAPx10_ASAP7_75t_R
XFILLER_50_112 VDD VSS DECAPx10_ASAP7_75t_R
XFILLER_50_134 VDD VSS DECAPx1_ASAP7_75t_R
XFILLER_50_144 VDD VSS DECAPx2_ASAP7_75t_R
XFILLER_50_157 VDD VSS DECAPx10_ASAP7_75t_R
XFILLER_50_179 VDD VSS DECAPx10_ASAP7_75t_R
XFILLER_50_201 VDD VSS DECAPx10_ASAP7_75t_R
XFILLER_50_223 VDD VSS DECAPx10_ASAP7_75t_R
XFILLER_50_245 VDD VSS DECAPx4_ASAP7_75t_R
XFILLER_51_2 VDD VSS DECAPx10_ASAP7_75t_R
XFILLER_51_24 VDD VSS DECAPx10_ASAP7_75t_R
XFILLER_51_46 VDD VSS DECAPx10_ASAP7_75t_R
XFILLER_51_68 VDD VSS DECAPx10_ASAP7_75t_R
XFILLER_51_90 VDD VSS DECAPx10_ASAP7_75t_R
XFILLER_51_112 VDD VSS DECAPx10_ASAP7_75t_R
XFILLER_51_134 VDD VSS DECAPx10_ASAP7_75t_R
XFILLER_51_156 VDD VSS DECAPx10_ASAP7_75t_R
XFILLER_51_178 VDD VSS DECAPx10_ASAP7_75t_R
XFILLER_51_200 VDD VSS DECAPx10_ASAP7_75t_R
XFILLER_51_222 VDD VSS DECAPx10_ASAP7_75t_R
XFILLER_51_244 VDD VSS DECAPx6_ASAP7_75t_R
.ENDS gcd
