* Complete RVT library from independently published official xACT PEX, commit e5bd25da72cd297b8c0ec6f77600e0cbaa1124d0.
* BSD 3-Clause License
*
* Copyright 2022 Lawrence T. Clark, Vinay Vashishtha, or Arizona State
* University
*
* Redistribution and use in source and binary forms, with or without
* modification, are permitted provided that the following conditions are met:
*
* 1. Redistributions of source code must retain the above copyright notice,
* this list of conditions and the following disclaimer.
*
* 2. Redistributions in binary form must reproduce the above copyright
* notice, this list of conditions and the following disclaimer in the
* documentation and/or other materials provided with the distribution.
*
* 3. Neither the name of the copyright holder nor the names of its
* contributors may be used to endorse or promote products derived from this
* software without specific prior written permission.
*
* THIS SOFTWARE IS PROVIDED BY THE COPYRIGHT HOLDERS AND CONTRIBUTORS "AS IS"
* AND ANY EXPRESS OR IMPLIED WARRANTIES, INCLUDING, BUT NOT LIMITED TO, THE
* IMPLIED WARRANTIES OF MERCHANTABILITY AND FITNESS FOR A PARTICULAR PURPOSE
* ARE DISCLAIMED. IN NO EVENT SHALL THE COPYRIGHT HOLDER OR CONTRIBUTORS BE
* LIABLE FOR ANY DIRECT, INDIRECT, INCIDENTAL, SPECIAL, EXEMPLARY, OR
* CONSEQUENTIAL DAMAGES (INCLUDING, BUT NOT LIMITED TO, PROCUREMENT OF
* SUBSTITUTE GOODS OR SERVICES; LOSS OF USE, DATA, OR PROFITS; OR BUSINESS
* INTERRUPTION) HOWEVER CAUSED AND ON ANY THEORY OF LIABILITY, WHETHER IN
* CONTRACT, STRICT LIABILITY, OR TORT (INCLUDING NEGLIGENCE OR OTHERWISE)
* ARISING IN ANY WAY OUT OF THE USE OF THIS SOFTWARE, EVEN IF ADVISED OF THE
* POSSIBILITY OF SUCH DAMAGE.

.SUBCKT A2O1A1Ixp33_ASAP7_75t_R A1 A2 B C VDD VSS Y
M0 noxref_10 A1 noxref_7 VSS nmos_rvt L=2e-08 W=8.1e-08 nfin=3
M1 VSS A2 noxref_10 VSS nmos_rvt L=2e-08 W=8.1e-08 nfin=3
M2 noxref_7 B VSS VSS nmos_rvt L=2e-08 W=8.1e-08 nfin=3
M3 Y C noxref_7 VSS nmos_rvt L=2e-08 W=8.1e-08 nfin=3
M4 VDD A1 N_M4_s VDD pmos_rvt L=2e-08 W=8.1e-08 nfin=3
M5 N_M4_s A2 VDD VDD pmos_rvt L=2e-08 W=8.1e-08 nfin=3
M6 Y B N_M4_s VDD pmos_rvt L=2e-08 W=8.1e-08 nfin=3
M7 VDD C Y VDD pmos_rvt L=2e-08 W=5.4e-08 nfin=2
.ENDS

.SUBCKT A2O1A1O1Ixp25_ASAP7_75t_R A1 A2 B C D VDD VSS Y
M0 noxref_12 A2 noxref_8 VSS nmos_rvt L=2e-08 W=8.1e-08 nfin=3
M1 VSS A1 noxref_12 VSS nmos_rvt L=2e-08 W=8.1e-08 nfin=3
M2 noxref_8 B VSS VSS nmos_rvt L=2e-08 W=8.1e-08 nfin=3
M3 Y C noxref_8 VSS nmos_rvt L=2e-08 W=8.1e-08 nfin=3
M4 VSS D Y VSS nmos_rvt L=2e-08 W=8.1e-08 nfin=3
M5 VDD A2 noxref_9 VDD pmos_rvt L=2e-08 W=8.1e-08 nfin=3
M6 noxref_9 A1 VDD VDD pmos_rvt L=2e-08 W=8.1e-08 nfin=3
M7 noxref_10 B noxref_9 VDD pmos_rvt L=2e-08 W=8.1e-08 nfin=3
M8 VDD C noxref_10 VDD pmos_rvt L=2e-08 W=8.1e-08 nfin=3
M9 Y D noxref_10 VDD pmos_rvt L=2e-08 W=8.1e-08 nfin=3
.ENDS

.SUBCKT AND2x2_ASAP7_75t_R A B VDD VSS Y
M0 N_M0_d B N_M0_s VSS nmos_rvt L=2e-08 W=8.1e-08 nfin=3
M1 VSS A N_M0_d VSS nmos_rvt L=2e-08 W=8.1e-08 nfin=3
M2 Y N_M0_s VSS VSS nmos_rvt L=2e-08 W=8.1e-08 nfin=3
M3 Y N_M0_s VSS VSS nmos_rvt L=2e-08 W=8.1e-08 nfin=3
M4 N_M0_s B VDD VDD pmos_rvt L=2e-08 W=5.4e-08 nfin=2
M5 VDD A N_M0_s VDD pmos_rvt L=2e-08 W=5.4e-08 nfin=2
M6 Y N_M0_s VDD VDD pmos_rvt L=2e-08 W=8.1e-08 nfin=3
M7 Y N_M0_s VDD VDD pmos_rvt L=2e-08 W=8.1e-08 nfin=3
.ENDS

.SUBCKT AND2x4_ASAP7_75t_R A B VDD VSS Y
M0 VSS A N_M0_s VSS nmos_rvt L=2e-08 W=8.1e-08 nfin=3
M1 N_M0_s B N_M1_s VSS nmos_rvt L=2e-08 W=8.1e-08 nfin=3
M2 N_M2_d B N_M1_s VSS nmos_rvt L=2e-08 W=8.1e-08 nfin=3
M3 VSS A N_M2_d VSS nmos_rvt L=2e-08 W=8.1e-08 nfin=3
M4 Y N_M1_s VSS VSS nmos_rvt L=2e-08 W=8.1e-08 nfin=3
M5 Y N_M1_s VSS VSS nmos_rvt L=2e-08 W=8.1e-08 nfin=3
M6 Y N_M1_s VSS VSS nmos_rvt L=2e-08 W=8.1e-08 nfin=3
M7 Y N_M1_s VSS VSS nmos_rvt L=2e-08 W=8.1e-08 nfin=3
M8 N_M1_s A VDD VDD pmos_rvt L=2e-08 W=5.4e-08 nfin=2
M9 VDD B N_M1_s VDD pmos_rvt L=2e-08 W=5.4e-08 nfin=2
M10 VDD B N_M1_s VDD pmos_rvt L=2e-08 W=5.4e-08 nfin=2
M11 N_M1_s A VDD VDD pmos_rvt L=2e-08 W=5.4e-08 nfin=2
M12 Y N_M1_s VDD VDD pmos_rvt L=2e-08 W=8.1e-08 nfin=3
M13 Y N_M1_s VDD VDD pmos_rvt L=2e-08 W=8.1e-08 nfin=3
M14 Y N_M1_s VDD VDD pmos_rvt L=2e-08 W=8.1e-08 nfin=3
M15 Y N_M1_s VDD VDD pmos_rvt L=2e-08 W=8.1e-08 nfin=3
.ENDS

.SUBCKT AND2x6_ASAP7_75t_R A B VDD VSS Y
M0 VSS A N_M0_s VSS nmos_rvt L=2e-08 W=8.1e-08 nfin=3
M1 N_M0_s B N_M1_s VSS nmos_rvt L=2e-08 W=8.1e-08 nfin=3
M2 N_M2_d B N_M1_s VSS nmos_rvt L=2e-08 W=8.1e-08 nfin=3
M3 VSS A N_M2_d VSS nmos_rvt L=2e-08 W=8.1e-08 nfin=3
M4 Y N_M1_s VSS VSS nmos_rvt L=2e-08 W=8.1e-08 nfin=3
M5 Y N_M1_s VSS VSS nmos_rvt L=2e-08 W=8.1e-08 nfin=3
M6 Y N_M1_s VSS VSS nmos_rvt L=2e-08 W=8.1e-08 nfin=3
M7 Y N_M1_s VSS VSS nmos_rvt L=2e-08 W=8.1e-08 nfin=3
M8 Y N_M1_s VSS VSS nmos_rvt L=2e-08 W=8.1e-08 nfin=3
M9 Y N_M1_s VSS VSS nmos_rvt L=2e-08 W=8.1e-08 nfin=3
M10 N_M1_s A VDD VDD pmos_rvt L=2e-08 W=5.4e-08 nfin=2
M11 VDD B N_M1_s VDD pmos_rvt L=2e-08 W=5.4e-08 nfin=2
M12 VDD B N_M1_s VDD pmos_rvt L=2e-08 W=5.4e-08 nfin=2
M13 N_M1_s A VDD VDD pmos_rvt L=2e-08 W=5.4e-08 nfin=2
M14 Y N_M1_s VDD VDD pmos_rvt L=2e-08 W=8.1e-08 nfin=3
M15 Y N_M1_s VDD VDD pmos_rvt L=2e-08 W=8.1e-08 nfin=3
M16 Y N_M1_s VDD VDD pmos_rvt L=2e-08 W=8.1e-08 nfin=3
M17 Y N_M1_s VDD VDD pmos_rvt L=2e-08 W=8.1e-08 nfin=3
M18 Y N_M1_s VDD VDD pmos_rvt L=2e-08 W=8.1e-08 nfin=3
M19 Y N_M1_s VDD VDD pmos_rvt L=2e-08 W=8.1e-08 nfin=3
.ENDS

.SUBCKT AND3x1_ASAP7_75t_R A B C VDD VSS Y
M0 N_M0_d A N_M0_s VSS nmos_rvt L=2e-08 W=8.1e-08 nfin=3
M1 N_M1_d B N_M0_d VSS nmos_rvt L=2e-08 W=8.1e-08 nfin=3
M2 VSS C N_M1_d VSS nmos_rvt L=2e-08 W=8.1e-08 nfin=3
M3 Y N_M0_s VSS VSS nmos_rvt L=2e-08 W=8.1e-08 nfin=3
M4 VDD A N_M0_s VDD pmos_rvt L=2e-08 W=8.1e-08 nfin=3
M5 N_M0_s B VDD VDD pmos_rvt L=2e-08 W=8.1e-08 nfin=3
M6 VDD C N_M0_s VDD pmos_rvt L=2e-08 W=8.1e-08 nfin=3
M7 Y N_M0_s VDD VDD pmos_rvt L=2e-08 W=8.1e-08 nfin=3
.ENDS

.SUBCKT AND3x2_ASAP7_75t_R A B C VDD VSS Y
M0 N_M0_d A N_M0_s VSS nmos_rvt L=2e-08 W=8.1e-08 nfin=3
M1 N_M1_d B N_M0_d VSS nmos_rvt L=2e-08 W=8.1e-08 nfin=3
M2 VSS C N_M1_d VSS nmos_rvt L=2e-08 W=8.1e-08 nfin=3
M3 Y N_M0_s VSS VSS nmos_rvt L=2e-08 W=8.1e-08 nfin=3
M4 Y N_M0_s VSS VSS nmos_rvt L=2e-08 W=8.1e-08 nfin=3
M5 VDD A N_M0_s VDD pmos_rvt L=2e-08 W=8.1e-08 nfin=3
M6 N_M0_s B VDD VDD pmos_rvt L=2e-08 W=8.1e-08 nfin=3
M7 VDD C N_M0_s VDD pmos_rvt L=2e-08 W=8.1e-08 nfin=3
M8 Y N_M0_s VDD VDD pmos_rvt L=2e-08 W=8.1e-08 nfin=3
M9 Y N_M0_s VDD VDD pmos_rvt L=2e-08 W=8.1e-08 nfin=3
.ENDS

.SUBCKT AND3x4_ASAP7_75t_R A B C VDD VSS Y
M0 Y N_M0_g VSS VSS nmos_rvt L=2e-08 W=8.1e-08 nfin=3
M1 Y N_M0_g VSS VSS nmos_rvt L=2e-08 W=8.1e-08 nfin=3
M2 Y N_M0_g VSS VSS nmos_rvt L=2e-08 W=8.1e-08 nfin=3
M3 Y N_M0_g VSS VSS nmos_rvt L=2e-08 W=8.1e-08 nfin=3
M4 N_M4_d C VSS VSS nmos_rvt L=2e-08 W=8.1e-08 nfin=3
M5 N_M4_d C VSS VSS nmos_rvt L=2e-08 W=8.1e-08 nfin=3
M6 N_M4_d B N_M6_s VSS nmos_rvt L=2e-08 W=8.1e-08 nfin=3
M7 N_M4_d B N_M6_s VSS nmos_rvt L=2e-08 W=8.1e-08 nfin=3
M8 N_M0_g A N_M6_s VSS nmos_rvt L=2e-08 W=8.1e-08 nfin=3
M9 N_M0_g A N_M6_s VSS nmos_rvt L=2e-08 W=8.1e-08 nfin=3
M10 Y N_M0_g VDD VDD pmos_rvt L=2e-08 W=8.1e-08 nfin=3
M11 Y N_M0_g VDD VDD pmos_rvt L=2e-08 W=8.1e-08 nfin=3
M12 Y N_M0_g VDD VDD pmos_rvt L=2e-08 W=8.1e-08 nfin=3
M13 Y N_M0_g VDD VDD pmos_rvt L=2e-08 W=8.1e-08 nfin=3
M14 N_M0_g C VDD VDD pmos_rvt L=2e-08 W=8.1e-08 nfin=3
M15 VDD B N_M0_g VDD pmos_rvt L=2e-08 W=8.1e-08 nfin=3
M16 VDD A N_M0_g VDD pmos_rvt L=2e-08 W=8.1e-08 nfin=3
.ENDS

.SUBCKT AND4x1_ASAP7_75t_R A B C D VDD VSS Y
M0 N_M0_d A N_M0_s VSS nmos_rvt L=2e-08 W=8.1e-08 nfin=3
M1 N_M1_d B N_M0_d VSS nmos_rvt L=2e-08 W=8.1e-08 nfin=3
M2 N_M2_d C N_M1_d VSS nmos_rvt L=2e-08 W=8.1e-08 nfin=3
M3 VSS D N_M2_d VSS nmos_rvt L=2e-08 W=8.1e-08 nfin=3
M4 Y N_M0_s VSS VSS nmos_rvt L=2e-08 W=8.1e-08 nfin=3
M5 N_M0_s A VDD VDD pmos_rvt L=2e-08 W=8.1e-08 nfin=3
M6 VDD B N_M0_s VDD pmos_rvt L=2e-08 W=8.1e-08 nfin=3
M7 N_M0_s C VDD VDD pmos_rvt L=2e-08 W=8.1e-08 nfin=3
M8 VDD D N_M0_s VDD pmos_rvt L=2e-08 W=8.1e-08 nfin=3
M9 Y N_M0_s VDD VDD pmos_rvt L=2e-08 W=8.1e-08 nfin=3
.ENDS

.SUBCKT AND4x2_ASAP7_75t_R A B C D VDD VSS Y
M0 Y N_M0_g VSS VSS nmos_rvt L=2e-08 W=8.1e-08 nfin=3
M1 Y N_M0_g VSS VSS nmos_rvt L=2e-08 W=8.1e-08 nfin=3
M2 N_M2_d D VSS VSS nmos_rvt L=2e-08 W=8.1e-08 nfin=3
M3 N_M3_d C N_M2_d VSS nmos_rvt L=2e-08 W=8.1e-08 nfin=3
M4 N_M4_d B N_M3_d VSS nmos_rvt L=2e-08 W=8.1e-08 nfin=3
M5 N_M0_g A N_M4_d VSS nmos_rvt L=2e-08 W=8.1e-08 nfin=3
M6 Y N_M0_g VDD VDD pmos_rvt L=2e-08 W=8.1e-08 nfin=3
M7 Y N_M0_g VDD VDD pmos_rvt L=2e-08 W=8.1e-08 nfin=3
M8 N_M0_g D VDD VDD pmos_rvt L=2e-08 W=8.1e-08 nfin=3
M9 VDD C N_M0_g VDD pmos_rvt L=2e-08 W=8.1e-08 nfin=3
M10 N_M0_g B VDD VDD pmos_rvt L=2e-08 W=8.1e-08 nfin=3
M11 VDD A N_M0_g VDD pmos_rvt L=2e-08 W=8.1e-08 nfin=3
.ENDS

.SUBCKT AND5x1_ASAP7_75t_R A B C D E VDD VSS Y
M0 N_M0_d A N_M0_s VSS nmos_rvt L=2e-08 W=8.1e-08 nfin=3
M1 N_M1_d B N_M0_d VSS nmos_rvt L=2e-08 W=8.1e-08 nfin=3
M2 N_M2_d C N_M1_d VSS nmos_rvt L=2e-08 W=8.1e-08 nfin=3
M3 N_M3_d D N_M2_d VSS nmos_rvt L=2e-08 W=8.1e-08 nfin=3
M4 VSS E N_M3_d VSS nmos_rvt L=2e-08 W=8.1e-08 nfin=3
M5 Y N_M0_s VSS VSS nmos_rvt L=2e-08 W=8.1e-08 nfin=3
M6 VDD A N_M0_s VDD pmos_rvt L=2e-08 W=5.4e-08 nfin=2
M7 N_M0_s B VDD VDD pmos_rvt L=2e-08 W=5.4e-08 nfin=2
M8 VDD C N_M0_s VDD pmos_rvt L=2e-08 W=5.4e-08 nfin=2
M9 N_M0_s D VDD VDD pmos_rvt L=2e-08 W=5.4e-08 nfin=2
M10 VDD E N_M0_s VDD pmos_rvt L=2e-08 W=5.4e-08 nfin=2
M11 Y N_M0_s VDD VDD pmos_rvt L=2e-08 W=8.1e-08 nfin=3
.ENDS

.SUBCKT AND5x2_ASAP7_75t_R A B C D E VDD VSS Y
M0 N_M0_d E VSS VSS nmos_rvt L=2e-08 W=8.1e-08 nfin=3
M1 N_M0_d E VSS VSS nmos_rvt L=2e-08 W=8.1e-08 nfin=3
M2 N_M0_d D N_M2_s VSS nmos_rvt L=2e-08 W=8.1e-08 nfin=3
M3 N_M0_d D N_M2_s VSS nmos_rvt L=2e-08 W=8.1e-08 nfin=3
M4 N_M4_d C N_M2_s VSS nmos_rvt L=2e-08 W=8.1e-08 nfin=3
M5 N_M4_d C N_M2_s VSS nmos_rvt L=2e-08 W=8.1e-08 nfin=3
M6 N_M4_d B N_M6_s VSS nmos_rvt L=2e-08 W=8.1e-08 nfin=3
M7 N_M4_d B N_M6_s VSS nmos_rvt L=2e-08 W=8.1e-08 nfin=3
M8 N_M8_d A N_M6_s VSS nmos_rvt L=2e-08 W=8.1e-08 nfin=3
M9 N_M8_d A N_M6_s VSS nmos_rvt L=2e-08 W=8.1e-08 nfin=3
M10 Y N_M8_d VSS VSS nmos_rvt L=2e-08 W=8.1e-08 nfin=3
M11 Y N_M8_d VSS VSS nmos_rvt L=2e-08 W=8.1e-08 nfin=3
M12 N_M8_d E VDD VDD pmos_rvt L=2e-08 W=8.1e-08 nfin=3
M13 VDD D N_M8_d VDD pmos_rvt L=2e-08 W=8.1e-08 nfin=3
M14 VDD C N_M8_d VDD pmos_rvt L=2e-08 W=8.1e-08 nfin=3
M15 VDD B N_M8_d VDD pmos_rvt L=2e-08 W=8.1e-08 nfin=3
M16 VDD A N_M8_d VDD pmos_rvt L=2e-08 W=8.1e-08 nfin=3
M17 Y N_M8_d VDD VDD pmos_rvt L=2e-08 W=8.1e-08 nfin=3
M18 Y N_M8_d VDD VDD pmos_rvt L=2e-08 W=8.1e-08 nfin=3
.ENDS

.SUBCKT AO211x2_ASAP7_75t_R A1 A2 B C VDD VSS Y
M0 noxref_11 A1 N_M0_s VSS nmos_rvt L=2e-08 W=8.1e-08 nfin=3
M1 VSS A2 noxref_11 VSS nmos_rvt L=2e-08 W=8.1e-08 nfin=3
M2 N_M0_s B VSS VSS nmos_rvt L=2e-08 W=5.4e-08 nfin=2
M3 VSS C N_M0_s VSS nmos_rvt L=2e-08 W=5.4e-08 nfin=2
M4 Y N_M0_s VSS VSS nmos_rvt L=2e-08 W=8.1e-08 nfin=3
M5 Y N_M0_s VSS VSS nmos_rvt L=2e-08 W=8.1e-08 nfin=3
M6 VDD A1 noxref_8 VDD pmos_rvt L=2e-08 W=8.1e-08 nfin=3
M7 VDD A1 noxref_8 VDD pmos_rvt L=2e-08 W=8.1e-08 nfin=3
M8 VDD A2 noxref_8 VDD pmos_rvt L=2e-08 W=8.1e-08 nfin=3
M9 VDD A2 noxref_8 VDD pmos_rvt L=2e-08 W=8.1e-08 nfin=3
M10 noxref_9 B noxref_8 VDD pmos_rvt L=2e-08 W=8.1e-08 nfin=3
M11 noxref_9 B noxref_8 VDD pmos_rvt L=2e-08 W=8.1e-08 nfin=3
M12 N_M0_s C noxref_9 VDD pmos_rvt L=2e-08 W=8.1e-08 nfin=3
M13 N_M0_s C noxref_9 VDD pmos_rvt L=2e-08 W=8.1e-08 nfin=3
M14 Y N_M0_s VDD VDD pmos_rvt L=2e-08 W=8.1e-08 nfin=3
M15 Y N_M0_s VDD VDD pmos_rvt L=2e-08 W=8.1e-08 nfin=3
.ENDS

.SUBCKT AO21x1_ASAP7_75t_R A1 A2 B VDD VSS Y
M0 noxref_9 A1 VSS VSS nmos_rvt L=2e-08 W=8.1e-08 nfin=3
M1 N_M1_d A2 noxref_9 VSS nmos_rvt L=2e-08 W=8.1e-08 nfin=3
M2 VSS B N_M1_d VSS nmos_rvt L=2e-08 W=8.1e-08 nfin=3
M3 Y N_M1_d VSS VSS nmos_rvt L=2e-08 W=8.1e-08 nfin=3
M4 N_M1_d A1 noxref_7 VDD pmos_rvt L=2e-08 W=8.1e-08 nfin=3
M5 noxref_7 A2 N_M1_d VDD pmos_rvt L=2e-08 W=8.1e-08 nfin=3
M6 VDD B noxref_7 VDD pmos_rvt L=2e-08 W=8.1e-08 nfin=3
M7 Y N_M1_d VDD VDD pmos_rvt L=2e-08 W=8.1e-08 nfin=3
.ENDS

.SUBCKT AO21x2_ASAP7_75t_R A1 A2 B VDD VSS Y
M0 noxref_9 A1 VSS VSS nmos_rvt L=2e-08 W=8.1e-08 nfin=3
M1 N_M1_d A2 noxref_9 VSS nmos_rvt L=2e-08 W=8.1e-08 nfin=3
M2 VSS B N_M1_d VSS nmos_rvt L=2e-08 W=8.1e-08 nfin=3
M3 Y N_M1_d VSS VSS nmos_rvt L=2e-08 W=8.1e-08 nfin=3
M4 Y N_M1_d VSS VSS nmos_rvt L=2e-08 W=8.1e-08 nfin=3
M5 N_M1_d A1 noxref_7 VDD pmos_rvt L=2e-08 W=8.1e-08 nfin=3
M6 noxref_7 A2 N_M1_d VDD pmos_rvt L=2e-08 W=8.1e-08 nfin=3
M7 VDD B noxref_7 VDD pmos_rvt L=2e-08 W=8.1e-08 nfin=3
M8 Y N_M1_d VDD VDD pmos_rvt L=2e-08 W=8.1e-08 nfin=3
M9 Y N_M1_d VDD VDD pmos_rvt L=2e-08 W=8.1e-08 nfin=3
.ENDS

.SUBCKT AO221x1_ASAP7_75t_R A1 A2 B1 B2 C VDD VSS Y
M0 noxref_12 B1 N_M0_s VSS nmos_rvt L=2e-08 W=5.4e-08 nfin=2
M1 VSS B2 noxref_12 VSS nmos_rvt L=2e-08 W=5.4e-08 nfin=2
M2 N_M0_s C VSS VSS nmos_rvt L=2e-08 W=5.4e-08 nfin=2
M3 noxref_13 A1 N_M0_s VSS nmos_rvt L=2e-08 W=5.4e-08 nfin=2
M4 VSS A2 noxref_13 VSS nmos_rvt L=2e-08 W=5.4e-08 nfin=2
M5 Y N_M0_s VSS VSS nmos_rvt L=2e-08 W=8.1e-08 nfin=3
M6 N_M0_s B1 noxref_9 VDD pmos_rvt L=2e-08 W=8.1e-08 nfin=3
M7 noxref_9 B2 N_M0_s VDD pmos_rvt L=2e-08 W=8.1e-08 nfin=3
M8 noxref_10 C noxref_9 VDD pmos_rvt L=2e-08 W=8.1e-08 nfin=3
M9 VDD A1 noxref_10 VDD pmos_rvt L=2e-08 W=8.1e-08 nfin=3
M10 noxref_10 A2 VDD VDD pmos_rvt L=2e-08 W=8.1e-08 nfin=3
M11 Y N_M0_s VDD VDD pmos_rvt L=2e-08 W=8.1e-08 nfin=3
.ENDS

.SUBCKT AO221x2_ASAP7_75t_R A1 A2 B1 B2 C VDD VSS Y
M0 noxref_12 B1 N_M0_s VSS nmos_rvt L=2e-08 W=5.4e-08 nfin=2
M1 VSS B2 noxref_12 VSS nmos_rvt L=2e-08 W=5.4e-08 nfin=2
M2 N_M0_s C VSS VSS nmos_rvt L=2e-08 W=5.4e-08 nfin=2
M3 noxref_13 A1 N_M0_s VSS nmos_rvt L=2e-08 W=5.4e-08 nfin=2
M4 VSS A2 noxref_13 VSS nmos_rvt L=2e-08 W=5.4e-08 nfin=2
M5 Y N_M0_s VSS VSS nmos_rvt L=2e-08 W=8.1e-08 nfin=3
M6 Y N_M0_s VSS VSS nmos_rvt L=2e-08 W=8.1e-08 nfin=3
M7 N_M0_s B1 noxref_9 VDD pmos_rvt L=2e-08 W=8.1e-08 nfin=3
M8 noxref_9 B2 N_M0_s VDD pmos_rvt L=2e-08 W=8.1e-08 nfin=3
M9 noxref_10 C noxref_9 VDD pmos_rvt L=2e-08 W=8.1e-08 nfin=3
M10 VDD A1 noxref_10 VDD pmos_rvt L=2e-08 W=8.1e-08 nfin=3
M11 noxref_10 A2 VDD VDD pmos_rvt L=2e-08 W=8.1e-08 nfin=3
M12 Y N_M0_s VDD VDD pmos_rvt L=2e-08 W=8.1e-08 nfin=3
M13 Y N_M0_s VDD VDD pmos_rvt L=2e-08 W=8.1e-08 nfin=3
.ENDS

.SUBCKT AO222x2_ASAP7_75t_R A1 A2 B1 B2 C1 C2 VDD VSS Y
M0 noxref_13 C1 N_M0_s VSS nmos_rvt L=2e-08 W=8.1e-08 nfin=3
M1 VSS C2 noxref_13 VSS nmos_rvt L=2e-08 W=8.1e-08 nfin=3
M2 noxref_14 B2 VSS VSS nmos_rvt L=2e-08 W=8.1e-08 nfin=3
M3 N_M0_s B1 noxref_14 VSS nmos_rvt L=2e-08 W=8.1e-08 nfin=3
M4 noxref_15 A1 N_M0_s VSS nmos_rvt L=2e-08 W=8.1e-08 nfin=3
M5 VSS A2 noxref_15 VSS nmos_rvt L=2e-08 W=8.1e-08 nfin=3
M6 Y N_M0_s VSS VSS nmos_rvt L=2e-08 W=8.1e-08 nfin=3
M7 Y N_M0_s VSS VSS nmos_rvt L=2e-08 W=8.1e-08 nfin=3
M8 N_M0_s C1 noxref_10 VDD pmos_rvt L=2e-08 W=8.1e-08 nfin=3
M9 noxref_10 C2 N_M0_s VDD pmos_rvt L=2e-08 W=8.1e-08 nfin=3
M10 noxref_11 B2 noxref_10 VDD pmos_rvt L=2e-08 W=8.1e-08 nfin=3
M11 noxref_10 B1 noxref_11 VDD pmos_rvt L=2e-08 W=8.1e-08 nfin=3
M12 noxref_11 A1 VDD VDD pmos_rvt L=2e-08 W=8.1e-08 nfin=3
M13 VDD A2 noxref_11 VDD pmos_rvt L=2e-08 W=8.1e-08 nfin=3
M14 Y N_M0_s VDD VDD pmos_rvt L=2e-08 W=8.1e-08 nfin=3
M15 Y N_M0_s VDD VDD pmos_rvt L=2e-08 W=8.1e-08 nfin=3
.ENDS

.SUBCKT AO22x1_ASAP7_75t_R A1 A2 B1 B2 VDD VSS Y
M0 noxref_10 A1 VSS VSS nmos_rvt L=2e-08 W=5.4e-08 nfin=2
M1 N_M1_d A2 noxref_10 VSS nmos_rvt L=2e-08 W=5.4e-08 nfin=2
M2 noxref_11 B2 N_M1_d VSS nmos_rvt L=2e-08 W=5.4e-08 nfin=2
M3 VSS B1 noxref_11 VSS nmos_rvt L=2e-08 W=5.4e-08 nfin=2
M4 Y N_M1_d VSS VSS nmos_rvt L=2e-08 W=8.1e-08 nfin=3
M5 VDD A1 noxref_8 VDD pmos_rvt L=2e-08 W=5.4e-08 nfin=2
M6 noxref_8 A2 VDD VDD pmos_rvt L=2e-08 W=5.4e-08 nfin=2
M7 N_M1_d B2 noxref_8 VDD pmos_rvt L=2e-08 W=5.4e-08 nfin=2
M8 noxref_8 B1 N_M1_d VDD pmos_rvt L=2e-08 W=5.4e-08 nfin=2
M9 Y N_M1_d VDD VDD pmos_rvt L=2e-08 W=8.1e-08 nfin=3
.ENDS

.SUBCKT AO22x2_ASAP7_75t_R A1 A2 B1 B2 VDD VSS Y
M0 noxref_10 A1 VSS VSS nmos_rvt L=2e-08 W=8.1e-08 nfin=3
M1 N_M1_d A2 noxref_10 VSS nmos_rvt L=2e-08 W=8.1e-08 nfin=3
M2 noxref_11 B2 N_M1_d VSS nmos_rvt L=2e-08 W=8.1e-08 nfin=3
M3 VSS B1 noxref_11 VSS nmos_rvt L=2e-08 W=8.1e-08 nfin=3
M4 Y N_M1_d VSS VSS nmos_rvt L=2e-08 W=8.1e-08 nfin=3
M5 Y N_M1_d VSS VSS nmos_rvt L=2e-08 W=8.1e-08 nfin=3
M6 VDD A1 noxref_8 VDD pmos_rvt L=2e-08 W=8.1e-08 nfin=3
M7 noxref_8 A2 VDD VDD pmos_rvt L=2e-08 W=8.1e-08 nfin=3
M8 N_M1_d B2 noxref_8 VDD pmos_rvt L=2e-08 W=8.1e-08 nfin=3
M9 noxref_8 B1 N_M1_d VDD pmos_rvt L=2e-08 W=8.1e-08 nfin=3
M10 Y N_M1_d VDD VDD pmos_rvt L=2e-08 W=8.1e-08 nfin=3
M11 Y N_M1_d VDD VDD pmos_rvt L=2e-08 W=8.1e-08 nfin=3
.ENDS

.SUBCKT AO31x2_ASAP7_75t_R A1 A2 A3 B VDD VSS Y
M0 noxref_9 A3 VSS VSS nmos_rvt L=2e-08 W=8.1e-08 nfin=3
M1 noxref_9 A3 VSS VSS nmos_rvt L=2e-08 W=8.1e-08 nfin=3
M2 N_M2_d B VSS VSS nmos_rvt L=2e-08 W=5.4e-08 nfin=2
M3 noxref_9 A2 noxref_10 VSS nmos_rvt L=2e-08 W=8.1e-08 nfin=3
M4 noxref_9 A2 noxref_10 VSS nmos_rvt L=2e-08 W=8.1e-08 nfin=3
M5 N_M2_d A1 noxref_10 VSS nmos_rvt L=2e-08 W=8.1e-08 nfin=3
M6 N_M2_d A1 noxref_10 VSS nmos_rvt L=2e-08 W=8.1e-08 nfin=3
M7 Y N_M2_d VSS VSS nmos_rvt L=2e-08 W=8.1e-08 nfin=3
M8 Y N_M2_d VSS VSS nmos_rvt L=2e-08 W=8.1e-08 nfin=3
M9 VDD A3 noxref_8 VDD pmos_rvt L=2e-08 W=8.1e-08 nfin=3
M10 VDD A3 noxref_8 VDD pmos_rvt L=2e-08 W=8.1e-08 nfin=3
M11 N_M2_d B noxref_8 VDD pmos_rvt L=2e-08 W=8.1e-08 nfin=3
M12 N_M2_d B noxref_8 VDD pmos_rvt L=2e-08 W=8.1e-08 nfin=3
M13 noxref_8 A2 VDD VDD pmos_rvt L=2e-08 W=8.1e-08 nfin=3
M14 noxref_8 A2 VDD VDD pmos_rvt L=2e-08 W=8.1e-08 nfin=3
M15 noxref_8 A1 VDD VDD pmos_rvt L=2e-08 W=8.1e-08 nfin=3
M16 noxref_8 A1 VDD VDD pmos_rvt L=2e-08 W=8.1e-08 nfin=3
M17 Y N_M2_d VDD VDD pmos_rvt L=2e-08 W=8.1e-08 nfin=3
M18 Y N_M2_d VDD VDD pmos_rvt L=2e-08 W=8.1e-08 nfin=3
.ENDS

.SUBCKT AO322x2_ASAP7_75t_R A1 A2 A3 B1 B2 C1 C2 VDD VSS Y
M0 noxref_14 A1 N_M0_s VSS nmos_rvt L=2e-08 W=8.1e-08 nfin=3
M1 noxref_15 A2 noxref_14 VSS nmos_rvt L=2e-08 W=8.1e-08 nfin=3
M2 VSS A3 noxref_15 VSS nmos_rvt L=2e-08 W=8.1e-08 nfin=3
M3 noxref_16 B2 VSS VSS nmos_rvt L=2e-08 W=5.4e-08 nfin=2
M4 N_M0_s B1 noxref_16 VSS nmos_rvt L=2e-08 W=5.4e-08 nfin=2
M5 noxref_17 C1 N_M0_s VSS nmos_rvt L=2e-08 W=5.4e-08 nfin=2
M6 VSS C2 noxref_17 VSS nmos_rvt L=2e-08 W=5.4e-08 nfin=2
M7 VSS N_M0_s Y VSS nmos_rvt L=2e-08 W=8.1e-08 nfin=3
M8 VSS N_M0_s Y VSS nmos_rvt L=2e-08 W=8.1e-08 nfin=3
M9 noxref_11 A1 VDD VDD pmos_rvt L=2e-08 W=8.1e-08 nfin=3
M10 VDD A2 noxref_11 VDD pmos_rvt L=2e-08 W=8.1e-08 nfin=3
M11 noxref_11 A3 VDD VDD pmos_rvt L=2e-08 W=8.1e-08 nfin=3
M12 noxref_12 B2 noxref_11 VDD pmos_rvt L=2e-08 W=8.1e-08 nfin=3
M13 noxref_11 B1 noxref_12 VDD pmos_rvt L=2e-08 W=8.1e-08 nfin=3
M14 noxref_12 C1 N_M0_s VDD pmos_rvt L=2e-08 W=8.1e-08 nfin=3
M15 N_M0_s C2 noxref_12 VDD pmos_rvt L=2e-08 W=8.1e-08 nfin=3
M16 VDD N_M0_s Y VDD pmos_rvt L=2e-08 W=8.1e-08 nfin=3
M17 VDD N_M0_s Y VDD pmos_rvt L=2e-08 W=8.1e-08 nfin=3
.ENDS

.SUBCKT AO32x1_ASAP7_75t_R A1 A2 A3 B1 B2 VDD VSS Y
M0 VSS N_M0_g Y VSS nmos_rvt L=2e-08 W=8.1e-08 nfin=3
M1 noxref_11 A3 VSS VSS nmos_rvt L=2e-08 W=8.1e-08 nfin=3
M2 noxref_12 A2 noxref_11 VSS nmos_rvt L=2e-08 W=8.1e-08 nfin=3
M3 N_M0_g A1 noxref_12 VSS nmos_rvt L=2e-08 W=8.1e-08 nfin=3
M4 noxref_13 B1 N_M0_g VSS nmos_rvt L=2e-08 W=5.4e-08 nfin=2
M5 VSS B2 noxref_13 VSS nmos_rvt L=2e-08 W=5.4e-08 nfin=2
M6 VDD N_M0_g Y VDD pmos_rvt L=2e-08 W=8.1e-08 nfin=3
M7 noxref_10 A3 VDD VDD pmos_rvt L=2e-08 W=5.4e-08 nfin=2
M8 VDD A2 noxref_10 VDD pmos_rvt L=2e-08 W=5.4e-08 nfin=2
M9 noxref_10 A1 VDD VDD pmos_rvt L=2e-08 W=5.4e-08 nfin=2
M10 N_M0_g B1 noxref_10 VDD pmos_rvt L=2e-08 W=5.4e-08 nfin=2
M11 noxref_10 B2 N_M0_g VDD pmos_rvt L=2e-08 W=5.4e-08 nfin=2
.ENDS

.SUBCKT AO32x2_ASAP7_75t_R A1 A2 A3 B1 B2 VDD VSS Y
M0 Y N_M0_g VSS VSS nmos_rvt L=2e-08 W=8.1e-08 nfin=3
M1 Y N_M0_g VSS VSS nmos_rvt L=2e-08 W=8.1e-08 nfin=3
M2 noxref_11 A3 VSS VSS nmos_rvt L=2e-08 W=8.1e-08 nfin=3
M3 noxref_12 A2 noxref_11 VSS nmos_rvt L=2e-08 W=8.1e-08 nfin=3
M4 N_M0_g A1 noxref_12 VSS nmos_rvt L=2e-08 W=8.1e-08 nfin=3
M5 noxref_13 B1 N_M0_g VSS nmos_rvt L=2e-08 W=5.4e-08 nfin=2
M6 VSS B2 noxref_13 VSS nmos_rvt L=2e-08 W=5.4e-08 nfin=2
M7 Y N_M0_g VDD VDD pmos_rvt L=2e-08 W=8.1e-08 nfin=3
M8 Y N_M0_g VDD VDD pmos_rvt L=2e-08 W=8.1e-08 nfin=3
M9 noxref_10 A3 VDD VDD pmos_rvt L=2e-08 W=5.4e-08 nfin=2
M10 VDD A2 noxref_10 VDD pmos_rvt L=2e-08 W=5.4e-08 nfin=2
M11 noxref_10 A1 VDD VDD pmos_rvt L=2e-08 W=5.4e-08 nfin=2
M12 N_M0_g B1 noxref_10 VDD pmos_rvt L=2e-08 W=5.4e-08 nfin=2
M13 noxref_10 B2 N_M0_g VDD pmos_rvt L=2e-08 W=5.4e-08 nfin=2
.ENDS

.SUBCKT AO331x1_ASAP7_75t_R A1 A2 A3 B1 B2 B3 C VDD VSS Y
M0 VSS N_M0_g Y VSS nmos_rvt L=2e-08 W=8.1e-08 nfin=3
M1 noxref_14 A3 VSS VSS nmos_rvt L=2e-08 W=8.1e-08 nfin=3
M2 noxref_15 A2 noxref_14 VSS nmos_rvt L=2e-08 W=8.1e-08 nfin=3
M3 N_M0_g A1 noxref_15 VSS nmos_rvt L=2e-08 W=8.1e-08 nfin=3
M4 noxref_16 B1 N_M0_g VSS nmos_rvt L=2e-08 W=8.1e-08 nfin=3
M5 noxref_17 B2 noxref_16 VSS nmos_rvt L=2e-08 W=8.1e-08 nfin=3
M6 VSS B3 noxref_17 VSS nmos_rvt L=2e-08 W=8.1e-08 nfin=3
M7 N_M0_g C VSS VSS nmos_rvt L=2e-08 W=8.1e-08 nfin=3
M8 VDD N_M0_g Y VDD pmos_rvt L=2e-08 W=8.1e-08 nfin=3
M9 noxref_12 A3 VDD VDD pmos_rvt L=2e-08 W=8.1e-08 nfin=3
M10 VDD A2 noxref_12 VDD pmos_rvt L=2e-08 W=8.1e-08 nfin=3
M11 noxref_12 A1 VDD VDD pmos_rvt L=2e-08 W=8.1e-08 nfin=3
M12 noxref_13 B1 noxref_12 VDD pmos_rvt L=2e-08 W=8.1e-08 nfin=3
M13 noxref_12 B2 noxref_13 VDD pmos_rvt L=2e-08 W=8.1e-08 nfin=3
M14 noxref_13 B3 noxref_12 VDD pmos_rvt L=2e-08 W=8.1e-08 nfin=3
M15 N_M0_g C noxref_13 VDD pmos_rvt L=2e-08 W=8.1e-08 nfin=3
.ENDS

.SUBCKT AO331x2_ASAP7_75t_R A1 A2 A3 B1 B2 B3 C VDD VSS Y
M0 Y N_M0_g VSS VSS nmos_rvt L=2e-08 W=8.1e-08 nfin=3
M1 Y N_M0_g VSS VSS nmos_rvt L=2e-08 W=8.1e-08 nfin=3
M2 noxref_14 A3 VSS VSS nmos_rvt L=2e-08 W=8.1e-08 nfin=3
M3 noxref_15 A2 noxref_14 VSS nmos_rvt L=2e-08 W=8.1e-08 nfin=3
M4 N_M0_g A1 noxref_15 VSS nmos_rvt L=2e-08 W=8.1e-08 nfin=3
M5 noxref_16 B1 N_M0_g VSS nmos_rvt L=2e-08 W=8.1e-08 nfin=3
M6 noxref_17 B2 noxref_16 VSS nmos_rvt L=2e-08 W=8.1e-08 nfin=3
M7 VSS B3 noxref_17 VSS nmos_rvt L=2e-08 W=8.1e-08 nfin=3
M8 N_M0_g C VSS VSS nmos_rvt L=2e-08 W=8.1e-08 nfin=3
M9 Y N_M0_g VDD VDD pmos_rvt L=2e-08 W=8.1e-08 nfin=3
M10 Y N_M0_g VDD VDD pmos_rvt L=2e-08 W=8.1e-08 nfin=3
M11 noxref_12 A3 VDD VDD pmos_rvt L=2e-08 W=8.1e-08 nfin=3
M12 VDD A2 noxref_12 VDD pmos_rvt L=2e-08 W=8.1e-08 nfin=3
M13 noxref_12 A1 VDD VDD pmos_rvt L=2e-08 W=8.1e-08 nfin=3
M14 noxref_13 B1 noxref_12 VDD pmos_rvt L=2e-08 W=8.1e-08 nfin=3
M15 noxref_12 B2 noxref_13 VDD pmos_rvt L=2e-08 W=8.1e-08 nfin=3
M16 noxref_13 B3 noxref_12 VDD pmos_rvt L=2e-08 W=8.1e-08 nfin=3
M17 N_M0_g C noxref_13 VDD pmos_rvt L=2e-08 W=8.1e-08 nfin=3
.ENDS

.SUBCKT AO332x1_ASAP7_75t_R A1 A2 A3 B1 B2 B3 C1 C2 VDD VSS Y
M0 VSS N_M0_g Y VSS nmos_rvt L=2e-08 W=8.1e-08 nfin=3
M1 noxref_15 A3 VSS VSS nmos_rvt L=2e-08 W=8.1e-08 nfin=3
M2 noxref_16 A2 noxref_15 VSS nmos_rvt L=2e-08 W=8.1e-08 nfin=3
M3 N_M0_g A1 noxref_16 VSS nmos_rvt L=2e-08 W=8.1e-08 nfin=3
M4 noxref_17 B1 N_M0_g VSS nmos_rvt L=2e-08 W=8.1e-08 nfin=3
M5 noxref_18 B2 noxref_17 VSS nmos_rvt L=2e-08 W=8.1e-08 nfin=3
M6 VSS B3 noxref_18 VSS nmos_rvt L=2e-08 W=8.1e-08 nfin=3
M7 noxref_19 C2 VSS VSS nmos_rvt L=2e-08 W=8.1e-08 nfin=3
M8 N_M0_g C1 noxref_19 VSS nmos_rvt L=2e-08 W=8.1e-08 nfin=3
M9 VDD N_M0_g Y VDD pmos_rvt L=2e-08 W=8.1e-08 nfin=3
M10 noxref_13 A3 VDD VDD pmos_rvt L=2e-08 W=8.1e-08 nfin=3
M11 VDD A2 noxref_13 VDD pmos_rvt L=2e-08 W=8.1e-08 nfin=3
M12 noxref_13 A1 VDD VDD pmos_rvt L=2e-08 W=8.1e-08 nfin=3
M13 noxref_14 B1 noxref_13 VDD pmos_rvt L=2e-08 W=8.1e-08 nfin=3
M14 noxref_13 B2 noxref_14 VDD pmos_rvt L=2e-08 W=8.1e-08 nfin=3
M15 noxref_14 B3 noxref_13 VDD pmos_rvt L=2e-08 W=8.1e-08 nfin=3
M16 N_M0_g C2 noxref_14 VDD pmos_rvt L=2e-08 W=8.1e-08 nfin=3
M17 noxref_14 C1 N_M0_g VDD pmos_rvt L=2e-08 W=8.1e-08 nfin=3
.ENDS

.SUBCKT AO332x2_ASAP7_75t_R A1 A2 A3 B1 B2 B3 C1 C2 VDD VSS Y
M0 Y N_M0_g VSS VSS nmos_rvt L=2e-08 W=8.1e-08 nfin=3
M1 Y N_M0_g VSS VSS nmos_rvt L=2e-08 W=8.1e-08 nfin=3
M2 noxref_15 A3 VSS VSS nmos_rvt L=2e-08 W=8.1e-08 nfin=3
M3 noxref_16 A2 noxref_15 VSS nmos_rvt L=2e-08 W=8.1e-08 nfin=3
M4 N_M0_g A1 noxref_16 VSS nmos_rvt L=2e-08 W=8.1e-08 nfin=3
M5 noxref_17 B1 N_M0_g VSS nmos_rvt L=2e-08 W=8.1e-08 nfin=3
M6 noxref_18 B2 noxref_17 VSS nmos_rvt L=2e-08 W=8.1e-08 nfin=3
M7 VSS B3 noxref_18 VSS nmos_rvt L=2e-08 W=8.1e-08 nfin=3
M8 noxref_19 C2 VSS VSS nmos_rvt L=2e-08 W=8.1e-08 nfin=3
M9 N_M0_g C1 noxref_19 VSS nmos_rvt L=2e-08 W=8.1e-08 nfin=3
M10 Y N_M0_g VDD VDD pmos_rvt L=2e-08 W=8.1e-08 nfin=3
M11 Y N_M0_g VDD VDD pmos_rvt L=2e-08 W=8.1e-08 nfin=3
M12 noxref_13 A3 VDD VDD pmos_rvt L=2e-08 W=8.1e-08 nfin=3
M13 VDD A2 noxref_13 VDD pmos_rvt L=2e-08 W=8.1e-08 nfin=3
M14 noxref_13 A1 VDD VDD pmos_rvt L=2e-08 W=8.1e-08 nfin=3
M15 noxref_14 B1 noxref_13 VDD pmos_rvt L=2e-08 W=8.1e-08 nfin=3
M16 noxref_13 B2 noxref_14 VDD pmos_rvt L=2e-08 W=8.1e-08 nfin=3
M17 noxref_14 B3 noxref_13 VDD pmos_rvt L=2e-08 W=8.1e-08 nfin=3
M18 N_M0_g C2 noxref_14 VDD pmos_rvt L=2e-08 W=8.1e-08 nfin=3
M19 noxref_14 C1 N_M0_g VDD pmos_rvt L=2e-08 W=8.1e-08 nfin=3
.ENDS

.SUBCKT AO333x1_ASAP7_75t_R A1 A2 A3 B1 B2 B3 C1 C2 C3 VDD VSS Y
M0 VSS N_M0_g Y VSS nmos_rvt L=2e-08 W=8.1e-08 nfin=3
M1 noxref_16 A3 VSS VSS nmos_rvt L=2e-08 W=8.1e-08 nfin=3
M2 noxref_17 A2 noxref_16 VSS nmos_rvt L=2e-08 W=8.1e-08 nfin=3
M3 N_M0_g A1 noxref_17 VSS nmos_rvt L=2e-08 W=8.1e-08 nfin=3
M4 noxref_18 B3 N_M0_g VSS nmos_rvt L=2e-08 W=8.1e-08 nfin=3
M5 noxref_19 B2 noxref_18 VSS nmos_rvt L=2e-08 W=8.1e-08 nfin=3
M6 VSS B1 noxref_19 VSS nmos_rvt L=2e-08 W=8.1e-08 nfin=3
M7 noxref_20 C3 VSS VSS nmos_rvt L=2e-08 W=8.1e-08 nfin=3
M8 noxref_21 C2 noxref_20 VSS nmos_rvt L=2e-08 W=8.1e-08 nfin=3
M9 N_M0_g C1 noxref_21 VSS nmos_rvt L=2e-08 W=8.1e-08 nfin=3
M10 VDD N_M0_g Y VDD pmos_rvt L=2e-08 W=8.1e-08 nfin=3
M11 noxref_14 A3 VDD VDD pmos_rvt L=2e-08 W=8.1e-08 nfin=3
M12 VDD A2 noxref_14 VDD pmos_rvt L=2e-08 W=8.1e-08 nfin=3
M13 noxref_14 A1 VDD VDD pmos_rvt L=2e-08 W=8.1e-08 nfin=3
M14 noxref_15 B3 noxref_14 VDD pmos_rvt L=2e-08 W=8.1e-08 nfin=3
M15 noxref_14 B2 noxref_15 VDD pmos_rvt L=2e-08 W=8.1e-08 nfin=3
M16 noxref_15 B1 noxref_14 VDD pmos_rvt L=2e-08 W=8.1e-08 nfin=3
M17 N_M0_g C3 noxref_15 VDD pmos_rvt L=2e-08 W=8.1e-08 nfin=3
M18 noxref_15 C2 N_M0_g VDD pmos_rvt L=2e-08 W=8.1e-08 nfin=3
M19 N_M0_g C1 noxref_15 VDD pmos_rvt L=2e-08 W=8.1e-08 nfin=3
.ENDS

.SUBCKT AO333x2_ASAP7_75t_R A1 A2 A3 B1 B2 B3 C1 C2 C3 VDD VSS Y
M0 Y N_M0_g VSS VSS nmos_rvt L=2e-08 W=8.1e-08 nfin=3
M1 Y N_M0_g VSS VSS nmos_rvt L=2e-08 W=8.1e-08 nfin=3
M2 noxref_16 A3 VSS VSS nmos_rvt L=2e-08 W=8.1e-08 nfin=3
M3 noxref_17 A2 noxref_16 VSS nmos_rvt L=2e-08 W=8.1e-08 nfin=3
M4 N_M0_g A1 noxref_17 VSS nmos_rvt L=2e-08 W=8.1e-08 nfin=3
M5 noxref_18 B3 N_M0_g VSS nmos_rvt L=2e-08 W=8.1e-08 nfin=3
M6 noxref_19 B2 noxref_18 VSS nmos_rvt L=2e-08 W=8.1e-08 nfin=3
M7 VSS B1 noxref_19 VSS nmos_rvt L=2e-08 W=8.1e-08 nfin=3
M8 noxref_20 C3 VSS VSS nmos_rvt L=2e-08 W=8.1e-08 nfin=3
M9 noxref_21 C2 noxref_20 VSS nmos_rvt L=2e-08 W=8.1e-08 nfin=3
M10 N_M0_g C1 noxref_21 VSS nmos_rvt L=2e-08 W=8.1e-08 nfin=3
M11 Y N_M0_g VDD VDD pmos_rvt L=2e-08 W=8.1e-08 nfin=3
M12 Y N_M0_g VDD VDD pmos_rvt L=2e-08 W=8.1e-08 nfin=3
M13 noxref_14 A3 VDD VDD pmos_rvt L=2e-08 W=8.1e-08 nfin=3
M14 VDD A2 noxref_14 VDD pmos_rvt L=2e-08 W=8.1e-08 nfin=3
M15 noxref_14 A1 VDD VDD pmos_rvt L=2e-08 W=8.1e-08 nfin=3
M16 noxref_15 B3 noxref_14 VDD pmos_rvt L=2e-08 W=8.1e-08 nfin=3
M17 noxref_14 B2 noxref_15 VDD pmos_rvt L=2e-08 W=8.1e-08 nfin=3
M18 noxref_15 B1 noxref_14 VDD pmos_rvt L=2e-08 W=8.1e-08 nfin=3
M19 N_M0_g C3 noxref_15 VDD pmos_rvt L=2e-08 W=8.1e-08 nfin=3
M20 noxref_15 C2 N_M0_g VDD pmos_rvt L=2e-08 W=8.1e-08 nfin=3
M21 N_M0_g C1 noxref_15 VDD pmos_rvt L=2e-08 W=8.1e-08 nfin=3
.ENDS

.SUBCKT AO33x2_ASAP7_75t_R A1 A2 A3 B1 B2 B3 VDD VSS Y
M0 Y N_M0_g VSS VSS nmos_rvt L=2e-08 W=8.1e-08 nfin=3
M1 Y N_M0_g VSS VSS nmos_rvt L=2e-08 W=8.1e-08 nfin=3
M2 noxref_12 A3 VSS VSS nmos_rvt L=2e-08 W=8.1e-08 nfin=3
M3 noxref_13 A2 noxref_12 VSS nmos_rvt L=2e-08 W=8.1e-08 nfin=3
M4 N_M0_g A1 noxref_13 VSS nmos_rvt L=2e-08 W=8.1e-08 nfin=3
M5 noxref_14 B1 N_M0_g VSS nmos_rvt L=2e-08 W=8.1e-08 nfin=3
M6 noxref_15 B2 noxref_14 VSS nmos_rvt L=2e-08 W=8.1e-08 nfin=3
M7 VSS B3 noxref_15 VSS nmos_rvt L=2e-08 W=8.1e-08 nfin=3
M8 Y N_M0_g VDD VDD pmos_rvt L=2e-08 W=8.1e-08 nfin=3
M9 Y N_M0_g VDD VDD pmos_rvt L=2e-08 W=8.1e-08 nfin=3
M10 noxref_11 A3 VDD VDD pmos_rvt L=2e-08 W=5.4e-08 nfin=2
M11 VDD A2 noxref_11 VDD pmos_rvt L=2e-08 W=5.4e-08 nfin=2
M12 noxref_11 A1 VDD VDD pmos_rvt L=2e-08 W=5.4e-08 nfin=2
M13 N_M0_g B1 noxref_11 VDD pmos_rvt L=2e-08 W=5.4e-08 nfin=2
M14 noxref_11 B2 N_M0_g VDD pmos_rvt L=2e-08 W=5.4e-08 nfin=2
M15 N_M0_g B3 noxref_11 VDD pmos_rvt L=2e-08 W=5.4e-08 nfin=2
.ENDS

.SUBCKT AOI211x1_ASAP7_75t_R A1 A2 B C VDD VSS Y
M0 noxref_10 A2 Y VSS nmos_rvt L=2e-08 W=8.1e-08 nfin=3
M1 VSS A1 noxref_10 VSS nmos_rvt L=2e-08 W=8.1e-08 nfin=3
M2 Y B VSS VSS nmos_rvt L=2e-08 W=8.1e-08 nfin=3
M3 VSS C Y VSS nmos_rvt L=2e-08 W=8.1e-08 nfin=3
M4 noxref_7 A2 VDD VDD pmos_rvt L=2e-08 W=8.1e-08 nfin=3
M5 noxref_7 A2 VDD VDD pmos_rvt L=2e-08 W=8.1e-08 nfin=3
M6 noxref_7 A1 VDD VDD pmos_rvt L=2e-08 W=8.1e-08 nfin=3
M7 noxref_7 A1 VDD VDD pmos_rvt L=2e-08 W=8.1e-08 nfin=3
M8 noxref_7 B noxref_8 VDD pmos_rvt L=2e-08 W=8.1e-08 nfin=3
M9 noxref_7 B noxref_8 VDD pmos_rvt L=2e-08 W=8.1e-08 nfin=3
M10 Y C noxref_8 VDD pmos_rvt L=2e-08 W=8.1e-08 nfin=3
M11 Y C noxref_8 VDD pmos_rvt L=2e-08 W=8.1e-08 nfin=3
.ENDS

.SUBCKT AOI211xp5_ASAP7_75t_R A1 A2 B C VDD VSS Y
M0 noxref_9 A2 Y VSS nmos_rvt L=2e-08 W=5.4e-08 nfin=2
M1 VSS A1 noxref_9 VSS nmos_rvt L=2e-08 W=5.4e-08 nfin=2
M2 Y B VSS VSS nmos_rvt L=2e-08 W=5.4e-08 nfin=2
M3 VSS C Y VSS nmos_rvt L=2e-08 W=5.4e-08 nfin=2
M4 Y A2 noxref_7 VDD pmos_rvt L=2e-08 W=8.1e-08 nfin=3
M5 noxref_7 A1 Y VDD pmos_rvt L=2e-08 W=8.1e-08 nfin=3
M6 noxref_10 B noxref_7 VDD pmos_rvt L=2e-08 W=8.1e-08 nfin=3
M7 VDD C noxref_10 VDD pmos_rvt L=2e-08 W=8.1e-08 nfin=3
.ENDS

.SUBCKT AOI21x1_ASAP7_75t_R A1 A2 B VDD VSS Y
M0 Y B VSS VSS nmos_rvt L=2e-08 W=5.4e-08 nfin=2
M1 Y A1 noxref_8 VSS nmos_rvt L=2e-08 W=8.1e-08 nfin=3
M2 noxref_8 A2 VSS VSS nmos_rvt L=2e-08 W=8.1e-08 nfin=3
M3 noxref_9 A2 VSS VSS nmos_rvt L=2e-08 W=8.1e-08 nfin=3
M4 Y A1 noxref_9 VSS nmos_rvt L=2e-08 W=8.1e-08 nfin=3
M5 Y B VSS VSS nmos_rvt L=2e-08 W=5.4e-08 nfin=2
M6 noxref_6 B Y VDD pmos_rvt L=2e-08 W=8.1e-08 nfin=3
M7 VDD A1 noxref_6 VDD pmos_rvt L=2e-08 W=8.1e-08 nfin=3
M8 noxref_6 A2 VDD VDD pmos_rvt L=2e-08 W=8.1e-08 nfin=3
M9 noxref_6 A2 VDD VDD pmos_rvt L=2e-08 W=8.1e-08 nfin=3
M10 VDD A1 noxref_6 VDD pmos_rvt L=2e-08 W=8.1e-08 nfin=3
M11 noxref_6 B Y VDD pmos_rvt L=2e-08 W=8.1e-08 nfin=3
.ENDS

.SUBCKT AOI21xp33_ASAP7_75t_R A1 A2 B VDD VSS Y
M0 noxref_8 A2 VSS VSS nmos_rvt L=2e-08 W=5.4e-08 nfin=2
M1 Y A1 noxref_8 VSS nmos_rvt L=2e-08 W=5.4e-08 nfin=2
M2 VSS B Y VSS nmos_rvt L=2e-08 W=5.4e-08 nfin=2
M3 VDD A2 noxref_6 VDD pmos_rvt L=2e-08 W=5.4e-08 nfin=2
M4 noxref_6 A1 VDD VDD pmos_rvt L=2e-08 W=5.4e-08 nfin=2
M5 Y B noxref_6 VDD pmos_rvt L=2e-08 W=5.4e-08 nfin=2
.ENDS

.SUBCKT AOI21xp5_ASAP7_75t_R A1 A2 B VDD VSS Y
M0 noxref_8 A2 VSS VSS nmos_rvt L=2e-08 W=8.1e-08 nfin=3
M1 Y A1 noxref_8 VSS nmos_rvt L=2e-08 W=8.1e-08 nfin=3
M2 VSS B Y VSS nmos_rvt L=2e-08 W=5.4e-08 nfin=2
M3 VDD A2 noxref_6 VDD pmos_rvt L=2e-08 W=8.1e-08 nfin=3
M4 noxref_6 A1 VDD VDD pmos_rvt L=2e-08 W=8.1e-08 nfin=3
M5 Y B noxref_6 VDD pmos_rvt L=2e-08 W=8.1e-08 nfin=3
.ENDS

.SUBCKT AOI221x1_ASAP7_75t_R A1 A2 B1 B2 C VDD VSS Y
M0 noxref_11 A2 VSS VSS nmos_rvt L=2e-08 W=8.1e-08 nfin=3
M1 Y A1 noxref_11 VSS nmos_rvt L=2e-08 W=8.1e-08 nfin=3
M2 noxref_12 B1 Y VSS nmos_rvt L=2e-08 W=8.1e-08 nfin=3
M3 VSS B2 noxref_12 VSS nmos_rvt L=2e-08 W=8.1e-08 nfin=3
M4 VSS C Y VSS nmos_rvt L=2e-08 W=5.4e-08 nfin=2
M5 VDD A2 noxref_8 VDD pmos_rvt L=2e-08 W=8.1e-08 nfin=3
M6 VDD A2 noxref_8 VDD pmos_rvt L=2e-08 W=8.1e-08 nfin=3
M7 VDD A1 noxref_8 VDD pmos_rvt L=2e-08 W=8.1e-08 nfin=3
M8 VDD A1 noxref_8 VDD pmos_rvt L=2e-08 W=8.1e-08 nfin=3
M9 noxref_9 B1 noxref_8 VDD pmos_rvt L=2e-08 W=8.1e-08 nfin=3
M10 noxref_9 B1 noxref_8 VDD pmos_rvt L=2e-08 W=8.1e-08 nfin=3
M11 noxref_9 B2 noxref_8 VDD pmos_rvt L=2e-08 W=8.1e-08 nfin=3
M12 noxref_9 B2 noxref_8 VDD pmos_rvt L=2e-08 W=8.1e-08 nfin=3
M13 Y C noxref_9 VDD pmos_rvt L=2e-08 W=8.1e-08 nfin=3
M14 Y C noxref_9 VDD pmos_rvt L=2e-08 W=8.1e-08 nfin=3
.ENDS

.SUBCKT AOI221xp5_ASAP7_75t_R A1 A2 B1 B2 C VDD VSS Y
M0 noxref_11 B1 Y VSS nmos_rvt L=2e-08 W=5.4e-08 nfin=2
M1 VSS B2 noxref_11 VSS nmos_rvt L=2e-08 W=5.4e-08 nfin=2
M2 Y C VSS VSS nmos_rvt L=2e-08 W=5.4e-08 nfin=2
M3 noxref_12 A1 Y VSS nmos_rvt L=2e-08 W=5.4e-08 nfin=2
M4 VSS A2 noxref_12 VSS nmos_rvt L=2e-08 W=5.4e-08 nfin=2
M5 Y B1 noxref_9 VDD pmos_rvt L=2e-08 W=8.1e-08 nfin=3
M6 noxref_9 B2 Y VDD pmos_rvt L=2e-08 W=8.1e-08 nfin=3
M7 noxref_10 C noxref_9 VDD pmos_rvt L=2e-08 W=8.1e-08 nfin=3
M8 VDD A1 noxref_10 VDD pmos_rvt L=2e-08 W=8.1e-08 nfin=3
M9 noxref_10 A2 VDD VDD pmos_rvt L=2e-08 W=8.1e-08 nfin=3
.ENDS

.SUBCKT AOI222xp33_ASAP7_75t_R A1 A2 B1 B2 C1 C2 VDD VSS Y
M0 noxref_12 A1 Y VSS nmos_rvt L=2e-08 W=5.4e-08 nfin=2
M1 VSS A2 noxref_12 VSS nmos_rvt L=2e-08 W=5.4e-08 nfin=2
M2 noxref_13 B2 VSS VSS nmos_rvt L=2e-08 W=5.4e-08 nfin=2
M3 Y B1 noxref_13 VSS nmos_rvt L=2e-08 W=5.4e-08 nfin=2
M4 noxref_14 C1 Y VSS nmos_rvt L=2e-08 W=5.4e-08 nfin=2
M5 VSS C2 noxref_14 VSS nmos_rvt L=2e-08 W=5.4e-08 nfin=2
M6 Y A1 noxref_10 VDD pmos_rvt L=2e-08 W=8.1e-08 nfin=3
M7 noxref_10 A2 Y VDD pmos_rvt L=2e-08 W=8.1e-08 nfin=3
M8 noxref_11 B2 noxref_10 VDD pmos_rvt L=2e-08 W=8.1e-08 nfin=3
M9 noxref_10 B1 noxref_11 VDD pmos_rvt L=2e-08 W=8.1e-08 nfin=3
M10 noxref_11 C1 VDD VDD pmos_rvt L=2e-08 W=8.1e-08 nfin=3
M11 VDD C2 noxref_11 VDD pmos_rvt L=2e-08 W=8.1e-08 nfin=3
.ENDS

.SUBCKT AOI22x1_ASAP7_75t_R A1 A2 B1 B2 VDD VSS Y
M0 Y B2 noxref_9 VSS nmos_rvt L=2e-08 W=8.1e-08 nfin=3
M1 noxref_9 B1 VSS VSS nmos_rvt L=2e-08 W=8.1e-08 nfin=3
M2 noxref_10 B1 VSS VSS nmos_rvt L=2e-08 W=8.1e-08 nfin=3
M3 Y B2 noxref_10 VSS nmos_rvt L=2e-08 W=8.1e-08 nfin=3
M4 Y A2 noxref_11 VSS nmos_rvt L=2e-08 W=8.1e-08 nfin=3
M5 noxref_11 A1 VSS VSS nmos_rvt L=2e-08 W=8.1e-08 nfin=3
M6 noxref_12 A1 VSS VSS nmos_rvt L=2e-08 W=8.1e-08 nfin=3
M7 Y A2 noxref_12 VSS nmos_rvt L=2e-08 W=8.1e-08 nfin=3
M8 VDD B2 noxref_7 VDD pmos_rvt L=2e-08 W=8.1e-08 nfin=3
M9 noxref_7 B1 VDD VDD pmos_rvt L=2e-08 W=8.1e-08 nfin=3
M10 noxref_7 B1 VDD VDD pmos_rvt L=2e-08 W=8.1e-08 nfin=3
M11 VDD B2 noxref_7 VDD pmos_rvt L=2e-08 W=8.1e-08 nfin=3
M12 Y A2 noxref_7 VDD pmos_rvt L=2e-08 W=8.1e-08 nfin=3
M13 noxref_7 A1 Y VDD pmos_rvt L=2e-08 W=8.1e-08 nfin=3
M14 noxref_7 A1 Y VDD pmos_rvt L=2e-08 W=8.1e-08 nfin=3
M15 Y A2 noxref_7 VDD pmos_rvt L=2e-08 W=8.1e-08 nfin=3
.ENDS

.SUBCKT AOI22xp33_ASAP7_75t_R A1 A2 B1 B2 VDD VSS Y
M0 noxref_9 A1 VSS VSS nmos_rvt L=2e-08 W=5.4e-08 nfin=2
M1 Y A2 noxref_9 VSS nmos_rvt L=2e-08 W=5.4e-08 nfin=2
M2 noxref_10 B2 Y VSS nmos_rvt L=2e-08 W=5.4e-08 nfin=2
M3 VSS B1 noxref_10 VSS nmos_rvt L=2e-08 W=5.4e-08 nfin=2
M4 VDD A1 noxref_7 VDD pmos_rvt L=2e-08 W=5.4e-08 nfin=2
M5 noxref_7 A2 VDD VDD pmos_rvt L=2e-08 W=5.4e-08 nfin=2
M6 Y B2 noxref_7 VDD pmos_rvt L=2e-08 W=5.4e-08 nfin=2
M7 noxref_7 B1 Y VDD pmos_rvt L=2e-08 W=5.4e-08 nfin=2
.ENDS

.SUBCKT AOI22xp5_ASAP7_75t_R A1 A2 B1 B2 VDD VSS Y
M0 noxref_9 A1 VSS VSS nmos_rvt L=2e-08 W=8.1e-08 nfin=3
M1 Y A2 noxref_9 VSS nmos_rvt L=2e-08 W=8.1e-08 nfin=3
M2 noxref_10 B2 Y VSS nmos_rvt L=2e-08 W=8.1e-08 nfin=3
M3 VSS B1 noxref_10 VSS nmos_rvt L=2e-08 W=8.1e-08 nfin=3
M4 VDD A1 noxref_7 VDD pmos_rvt L=2e-08 W=8.1e-08 nfin=3
M5 noxref_7 A2 VDD VDD pmos_rvt L=2e-08 W=8.1e-08 nfin=3
M6 Y B2 noxref_7 VDD pmos_rvt L=2e-08 W=8.1e-08 nfin=3
M7 noxref_7 B1 Y VDD pmos_rvt L=2e-08 W=8.1e-08 nfin=3
.ENDS

.SUBCKT AOI311xp33_ASAP7_75t_R A1 A2 A3 B C VDD VSS Y
M0 noxref_10 A3 VSS VSS nmos_rvt L=2e-08 W=8.1e-08 nfin=3
M1 noxref_11 A2 noxref_10 VSS nmos_rvt L=2e-08 W=8.1e-08 nfin=3
M2 Y A1 noxref_11 VSS nmos_rvt L=2e-08 W=8.1e-08 nfin=3
M3 VSS B Y VSS nmos_rvt L=2e-08 W=5.4e-08 nfin=2
M4 Y C VSS VSS nmos_rvt L=2e-08 W=5.4e-08 nfin=2
M5 noxref_8 A3 VDD VDD pmos_rvt L=2e-08 W=8.1e-08 nfin=3
M6 VDD A2 noxref_8 VDD pmos_rvt L=2e-08 W=8.1e-08 nfin=3
M7 noxref_8 A1 VDD VDD pmos_rvt L=2e-08 W=8.1e-08 nfin=3
M8 noxref_12 B noxref_8 VDD pmos_rvt L=2e-08 W=8.1e-08 nfin=3
M9 Y C noxref_12 VDD pmos_rvt L=2e-08 W=8.1e-08 nfin=3
.ENDS

.SUBCKT AOI31xp33_ASAP7_75t_R A1 A2 A3 B VDD VSS Y
M0 noxref_9 A3 VSS VSS nmos_rvt L=2e-08 W=8.1e-08 nfin=3
M1 noxref_10 A2 noxref_9 VSS nmos_rvt L=2e-08 W=8.1e-08 nfin=3
M2 Y A1 noxref_10 VSS nmos_rvt L=2e-08 W=8.1e-08 nfin=3
M3 VSS B Y VSS nmos_rvt L=2e-08 W=5.4e-08 nfin=2
M4 noxref_7 A3 VDD VDD pmos_rvt L=2e-08 W=5.4e-08 nfin=2
M5 VDD A2 noxref_7 VDD pmos_rvt L=2e-08 W=5.4e-08 nfin=2
M6 noxref_7 A1 VDD VDD pmos_rvt L=2e-08 W=5.4e-08 nfin=2
M7 Y B noxref_7 VDD pmos_rvt L=2e-08 W=5.4e-08 nfin=2
.ENDS

.SUBCKT AOI31xp67_ASAP7_75t_R A1 A2 A3 B VDD VSS Y
M0 noxref_8 A3 VSS VSS nmos_rvt L=2e-08 W=8.1e-08 nfin=3
M1 noxref_8 A3 VSS VSS nmos_rvt L=2e-08 W=8.1e-08 nfin=3
M2 Y B VSS VSS nmos_rvt L=2e-08 W=5.4e-08 nfin=2
M3 noxref_8 A2 noxref_9 VSS nmos_rvt L=2e-08 W=8.1e-08 nfin=3
M4 noxref_8 A2 noxref_9 VSS nmos_rvt L=2e-08 W=8.1e-08 nfin=3
M5 Y A1 noxref_9 VSS nmos_rvt L=2e-08 W=8.1e-08 nfin=3
M6 Y A1 noxref_9 VSS nmos_rvt L=2e-08 W=8.1e-08 nfin=3
M7 VDD A3 noxref_7 VDD pmos_rvt L=2e-08 W=8.1e-08 nfin=3
M8 VDD A3 noxref_7 VDD pmos_rvt L=2e-08 W=8.1e-08 nfin=3
M9 Y B noxref_7 VDD pmos_rvt L=2e-08 W=8.1e-08 nfin=3
M10 Y B noxref_7 VDD pmos_rvt L=2e-08 W=8.1e-08 nfin=3
M11 noxref_7 A2 VDD VDD pmos_rvt L=2e-08 W=8.1e-08 nfin=3
M12 noxref_7 A2 VDD VDD pmos_rvt L=2e-08 W=8.1e-08 nfin=3
M13 noxref_7 A1 VDD VDD pmos_rvt L=2e-08 W=8.1e-08 nfin=3
M14 noxref_7 A1 VDD VDD pmos_rvt L=2e-08 W=8.1e-08 nfin=3
.ENDS

.SUBCKT AOI321xp33_ASAP7_75t_R A1 A2 A3 B1 B2 C VDD VSS Y
M0 noxref_12 A3 VSS VSS nmos_rvt L=2e-08 W=8.1e-08 nfin=3
M1 noxref_13 A2 noxref_12 VSS nmos_rvt L=2e-08 W=8.1e-08 nfin=3
M2 Y A1 noxref_13 VSS nmos_rvt L=2e-08 W=8.1e-08 nfin=3
M3 VSS C Y VSS nmos_rvt L=2e-08 W=5.4e-08 nfin=2
M4 noxref_14 B1 VSS VSS nmos_rvt L=2e-08 W=5.4e-08 nfin=2
M5 Y B2 noxref_14 VSS nmos_rvt L=2e-08 W=5.4e-08 nfin=2
M6 noxref_9 A3 VDD VDD pmos_rvt L=2e-08 W=8.1e-08 nfin=3
M7 VDD A2 noxref_9 VDD pmos_rvt L=2e-08 W=8.1e-08 nfin=3
M8 noxref_9 A1 VDD VDD pmos_rvt L=2e-08 W=8.1e-08 nfin=3
M9 noxref_10 C noxref_9 VDD pmos_rvt L=2e-08 W=8.1e-08 nfin=3
M10 Y B1 noxref_10 VDD pmos_rvt L=2e-08 W=8.1e-08 nfin=3
M11 noxref_10 B2 Y VDD pmos_rvt L=2e-08 W=8.1e-08 nfin=3
.ENDS

.SUBCKT AOI322xp5_ASAP7_75t_R A1 A2 A3 B1 B2 C1 C2 VDD VSS Y
M0 noxref_13 B2 VSS VSS nmos_rvt L=2e-08 W=5.4e-08 nfin=2
M1 Y B1 noxref_13 VSS nmos_rvt L=2e-08 W=5.4e-08 nfin=2
M2 noxref_14 A1 Y VSS nmos_rvt L=2e-08 W=8.1e-08 nfin=3
M3 noxref_15 A2 noxref_14 VSS nmos_rvt L=2e-08 W=8.1e-08 nfin=3
M4 VSS A3 noxref_15 VSS nmos_rvt L=2e-08 W=8.1e-08 nfin=3
M5 noxref_16 C2 VSS VSS nmos_rvt L=2e-08 W=5.4e-08 nfin=2
M6 Y C1 noxref_16 VSS nmos_rvt L=2e-08 W=5.4e-08 nfin=2
M7 VDD B2 noxref_10 VDD pmos_rvt L=2e-08 W=8.1e-08 nfin=3
M8 noxref_10 B1 VDD VDD pmos_rvt L=2e-08 W=8.1e-08 nfin=3
M9 noxref_11 A1 noxref_10 VDD pmos_rvt L=2e-08 W=8.1e-08 nfin=3
M10 noxref_10 A2 noxref_11 VDD pmos_rvt L=2e-08 W=8.1e-08 nfin=3
M11 noxref_11 A3 noxref_10 VDD pmos_rvt L=2e-08 W=8.1e-08 nfin=3
M12 Y C2 noxref_11 VDD pmos_rvt L=2e-08 W=8.1e-08 nfin=3
M13 noxref_11 C1 Y VDD pmos_rvt L=2e-08 W=8.1e-08 nfin=3
.ENDS

.SUBCKT AOI32xp33_ASAP7_75t_R A1 A2 A3 B1 B2 VDD VSS Y
M0 noxref_10 A1 Y VSS nmos_rvt L=2e-08 W=8.1e-08 nfin=3
M1 noxref_11 A2 noxref_10 VSS nmos_rvt L=2e-08 W=8.1e-08 nfin=3
M2 VSS A3 noxref_11 VSS nmos_rvt L=2e-08 W=8.1e-08 nfin=3
M3 noxref_12 B1 VSS VSS nmos_rvt L=2e-08 W=5.4e-08 nfin=2
M4 Y B2 noxref_12 VSS nmos_rvt L=2e-08 W=5.4e-08 nfin=2
M5 noxref_8 A1 VDD VDD pmos_rvt L=2e-08 W=5.4e-08 nfin=2
M6 VDD A2 noxref_8 VDD pmos_rvt L=2e-08 W=5.4e-08 nfin=2
M7 noxref_8 A3 VDD VDD pmos_rvt L=2e-08 W=5.4e-08 nfin=2
M8 Y B1 noxref_8 VDD pmos_rvt L=2e-08 W=5.4e-08 nfin=2
M9 noxref_8 B2 Y VDD pmos_rvt L=2e-08 W=5.4e-08 nfin=2
.ENDS

.SUBCKT AOI331xp33_ASAP7_75t_R A1 A2 A3 B1 B2 B3 C1 VDD VSS Y
M0 noxref_13 A3 VSS VSS nmos_rvt L=2e-08 W=8.1e-08 nfin=3
M1 noxref_14 A2 noxref_13 VSS nmos_rvt L=2e-08 W=8.1e-08 nfin=3
M2 Y A1 noxref_14 VSS nmos_rvt L=2e-08 W=8.1e-08 nfin=3
M3 noxref_15 B1 Y VSS nmos_rvt L=2e-08 W=8.1e-08 nfin=3
M4 noxref_16 B2 noxref_15 VSS nmos_rvt L=2e-08 W=8.1e-08 nfin=3
M5 VSS B3 noxref_16 VSS nmos_rvt L=2e-08 W=8.1e-08 nfin=3
M6 Y C1 VSS VSS nmos_rvt L=2e-08 W=8.1e-08 nfin=3
M7 noxref_10 A3 VDD VDD pmos_rvt L=2e-08 W=8.1e-08 nfin=3
M8 VDD A2 noxref_10 VDD pmos_rvt L=2e-08 W=8.1e-08 nfin=3
M9 noxref_10 A1 VDD VDD pmos_rvt L=2e-08 W=8.1e-08 nfin=3
M10 noxref_11 B1 noxref_10 VDD pmos_rvt L=2e-08 W=8.1e-08 nfin=3
M11 noxref_10 B2 noxref_11 VDD pmos_rvt L=2e-08 W=8.1e-08 nfin=3
M12 noxref_11 B3 noxref_10 VDD pmos_rvt L=2e-08 W=8.1e-08 nfin=3
M13 Y C1 noxref_11 VDD pmos_rvt L=2e-08 W=8.1e-08 nfin=3
.ENDS

.SUBCKT AOI332xp33_ASAP7_75t_R A1 A2 A3 B1 B2 B3 C1 C2 VDD VSS Y
M0 noxref_14 A3 VSS VSS nmos_rvt L=2e-08 W=8.1e-08 nfin=3
M1 noxref_15 A2 noxref_14 VSS nmos_rvt L=2e-08 W=8.1e-08 nfin=3
M2 Y A1 noxref_15 VSS nmos_rvt L=2e-08 W=8.1e-08 nfin=3
M3 noxref_16 B1 Y VSS nmos_rvt L=2e-08 W=8.1e-08 nfin=3
M4 noxref_17 B2 noxref_16 VSS nmos_rvt L=2e-08 W=8.1e-08 nfin=3
M5 VSS B3 noxref_17 VSS nmos_rvt L=2e-08 W=8.1e-08 nfin=3
M6 noxref_18 C2 VSS VSS nmos_rvt L=2e-08 W=8.1e-08 nfin=3
M7 Y C1 noxref_18 VSS nmos_rvt L=2e-08 W=8.1e-08 nfin=3
M8 noxref_11 A3 VDD VDD pmos_rvt L=2e-08 W=8.1e-08 nfin=3
M9 VDD A2 noxref_11 VDD pmos_rvt L=2e-08 W=8.1e-08 nfin=3
M10 noxref_11 A1 VDD VDD pmos_rvt L=2e-08 W=8.1e-08 nfin=3
M11 noxref_12 B1 noxref_11 VDD pmos_rvt L=2e-08 W=8.1e-08 nfin=3
M12 noxref_11 B2 noxref_12 VDD pmos_rvt L=2e-08 W=8.1e-08 nfin=3
M13 noxref_12 B3 noxref_11 VDD pmos_rvt L=2e-08 W=8.1e-08 nfin=3
M14 Y C2 noxref_12 VDD pmos_rvt L=2e-08 W=8.1e-08 nfin=3
M15 noxref_12 C1 Y VDD pmos_rvt L=2e-08 W=8.1e-08 nfin=3
.ENDS

.SUBCKT AOI333xp33_ASAP7_75t_R A1 A2 A3 B1 B2 B3 C1 C2 C3 VDD VSS Y
M0 noxref_15 C3 VSS VSS nmos_rvt L=2e-08 W=8.1e-08 nfin=3
M1 noxref_16 C2 noxref_15 VSS nmos_rvt L=2e-08 W=8.1e-08 nfin=3
M2 Y C1 noxref_16 VSS nmos_rvt L=2e-08 W=8.1e-08 nfin=3
M3 noxref_17 B1 Y VSS nmos_rvt L=2e-08 W=8.1e-08 nfin=3
M4 noxref_18 B2 noxref_17 VSS nmos_rvt L=2e-08 W=8.1e-08 nfin=3
M5 VSS B3 noxref_18 VSS nmos_rvt L=2e-08 W=8.1e-08 nfin=3
M6 noxref_19 A3 VSS VSS nmos_rvt L=2e-08 W=8.1e-08 nfin=3
M7 noxref_20 A2 noxref_19 VSS nmos_rvt L=2e-08 W=8.1e-08 nfin=3
M8 Y A1 noxref_20 VSS nmos_rvt L=2e-08 W=8.1e-08 nfin=3
M9 noxref_12 C3 VDD VDD pmos_rvt L=2e-08 W=8.1e-08 nfin=3
M10 VDD C2 noxref_12 VDD pmos_rvt L=2e-08 W=8.1e-08 nfin=3
M11 noxref_12 C1 VDD VDD pmos_rvt L=2e-08 W=8.1e-08 nfin=3
M12 noxref_13 B1 noxref_12 VDD pmos_rvt L=2e-08 W=8.1e-08 nfin=3
M13 noxref_12 B2 noxref_13 VDD pmos_rvt L=2e-08 W=8.1e-08 nfin=3
M14 noxref_13 B3 noxref_12 VDD pmos_rvt L=2e-08 W=8.1e-08 nfin=3
M15 Y A3 noxref_13 VDD pmos_rvt L=2e-08 W=8.1e-08 nfin=3
M16 noxref_13 A2 Y VDD pmos_rvt L=2e-08 W=8.1e-08 nfin=3
M17 Y A1 noxref_13 VDD pmos_rvt L=2e-08 W=8.1e-08 nfin=3
.ENDS

.SUBCKT AOI33xp33_ASAP7_75t_R A1 A2 A3 B1 B2 B3 VDD VSS Y
M0 noxref_11 A1 VSS VSS nmos_rvt L=2e-08 W=8.1e-08 nfin=3
M1 noxref_12 A2 noxref_11 VSS nmos_rvt L=2e-08 W=8.1e-08 nfin=3
M2 Y A3 noxref_12 VSS nmos_rvt L=2e-08 W=8.1e-08 nfin=3
M3 noxref_13 B1 Y VSS nmos_rvt L=2e-08 W=8.1e-08 nfin=3
M4 noxref_14 B2 noxref_13 VSS nmos_rvt L=2e-08 W=8.1e-08 nfin=3
M5 VSS B3 noxref_14 VSS nmos_rvt L=2e-08 W=8.1e-08 nfin=3
M6 noxref_9 A1 VDD VDD pmos_rvt L=2e-08 W=5.4e-08 nfin=2
M7 VDD A2 noxref_9 VDD pmos_rvt L=2e-08 W=5.4e-08 nfin=2
M8 noxref_9 A3 VDD VDD pmos_rvt L=2e-08 W=5.4e-08 nfin=2
M9 Y B1 noxref_9 VDD pmos_rvt L=2e-08 W=5.4e-08 nfin=2
M10 noxref_9 B2 Y VDD pmos_rvt L=2e-08 W=5.4e-08 nfin=2
M11 Y B3 noxref_9 VDD pmos_rvt L=2e-08 W=5.4e-08 nfin=2
.ENDS

.SUBCKT BUFx10_ASAP7_75t_R A VDD VSS Y
M0 N_M0_d A VSS VSS nmos_rvt L=2e-08 W=8.1e-08 nfin=3
M1 N_M0_d A VSS VSS nmos_rvt L=2e-08 W=8.1e-08 nfin=3
M2 Y N_M0_d VSS VSS nmos_rvt L=2e-08 W=8.1e-08 nfin=3
M3 Y N_M0_d VSS VSS nmos_rvt L=2e-08 W=8.1e-08 nfin=3
M4 Y N_M0_d VSS VSS nmos_rvt L=2e-08 W=8.1e-08 nfin=3
M5 Y N_M0_d VSS VSS nmos_rvt L=2e-08 W=8.1e-08 nfin=3
M6 Y N_M0_d VSS VSS nmos_rvt L=2e-08 W=8.1e-08 nfin=3
M7 Y N_M0_d VSS VSS nmos_rvt L=2e-08 W=8.1e-08 nfin=3
M8 Y N_M0_d VSS VSS nmos_rvt L=2e-08 W=8.1e-08 nfin=3
M9 Y N_M0_d VSS VSS nmos_rvt L=2e-08 W=8.1e-08 nfin=3
M10 Y N_M0_d VSS VSS nmos_rvt L=2e-08 W=8.1e-08 nfin=3
M11 Y N_M0_d VSS VSS nmos_rvt L=2e-08 W=8.1e-08 nfin=3
M12 N_M0_d A VDD VDD pmos_rvt L=2e-08 W=8.1e-08 nfin=3
M13 N_M0_d A VDD VDD pmos_rvt L=2e-08 W=8.1e-08 nfin=3
M14 Y N_M0_d VDD VDD pmos_rvt L=2e-08 W=8.1e-08 nfin=3
M15 Y N_M0_d VDD VDD pmos_rvt L=2e-08 W=8.1e-08 nfin=3
M16 Y N_M0_d VDD VDD pmos_rvt L=2e-08 W=8.1e-08 nfin=3
M17 Y N_M0_d VDD VDD pmos_rvt L=2e-08 W=8.1e-08 nfin=3
M18 Y N_M0_d VDD VDD pmos_rvt L=2e-08 W=8.1e-08 nfin=3
M19 Y N_M0_d VDD VDD pmos_rvt L=2e-08 W=8.1e-08 nfin=3
M20 Y N_M0_d VDD VDD pmos_rvt L=2e-08 W=8.1e-08 nfin=3
M21 Y N_M0_d VDD VDD pmos_rvt L=2e-08 W=8.1e-08 nfin=3
M22 Y N_M0_d VDD VDD pmos_rvt L=2e-08 W=8.1e-08 nfin=3
M23 Y N_M0_d VDD VDD pmos_rvt L=2e-08 W=8.1e-08 nfin=3
.ENDS

.SUBCKT BUFx12_ASAP7_75t_R A VDD VSS Y
M0 N_M0_d A VSS VSS nmos_rvt L=2e-08 W=8.1e-08 nfin=3
M1 N_M0_d A VSS VSS nmos_rvt L=2e-08 W=8.1e-08 nfin=3
M2 Y N_M0_d VSS VSS nmos_rvt L=2e-08 W=8.1e-08 nfin=3
M3 Y N_M0_d VSS VSS nmos_rvt L=2e-08 W=8.1e-08 nfin=3
M4 Y N_M0_d VSS VSS nmos_rvt L=2e-08 W=8.1e-08 nfin=3
M5 Y N_M0_d VSS VSS nmos_rvt L=2e-08 W=8.1e-08 nfin=3
M6 Y N_M0_d VSS VSS nmos_rvt L=2e-08 W=8.1e-08 nfin=3
M7 Y N_M0_d VSS VSS nmos_rvt L=2e-08 W=8.1e-08 nfin=3
M8 Y N_M0_d VSS VSS nmos_rvt L=2e-08 W=8.1e-08 nfin=3
M9 Y N_M0_d VSS VSS nmos_rvt L=2e-08 W=8.1e-08 nfin=3
M10 Y N_M0_d VSS VSS nmos_rvt L=2e-08 W=8.1e-08 nfin=3
M11 Y N_M0_d VSS VSS nmos_rvt L=2e-08 W=8.1e-08 nfin=3
M12 Y N_M0_d VSS VSS nmos_rvt L=2e-08 W=8.1e-08 nfin=3
M13 Y N_M0_d VSS VSS nmos_rvt L=2e-08 W=8.1e-08 nfin=3
M14 N_M0_d A VDD VDD pmos_rvt L=2e-08 W=8.1e-08 nfin=3
M15 N_M0_d A VDD VDD pmos_rvt L=2e-08 W=8.1e-08 nfin=3
M16 Y N_M0_d VDD VDD pmos_rvt L=2e-08 W=8.1e-08 nfin=3
M17 Y N_M0_d VDD VDD pmos_rvt L=2e-08 W=8.1e-08 nfin=3
M18 Y N_M0_d VDD VDD pmos_rvt L=2e-08 W=8.1e-08 nfin=3
M19 Y N_M0_d VDD VDD pmos_rvt L=2e-08 W=8.1e-08 nfin=3
M20 Y N_M0_d VDD VDD pmos_rvt L=2e-08 W=8.1e-08 nfin=3
M21 Y N_M0_d VDD VDD pmos_rvt L=2e-08 W=8.1e-08 nfin=3
M22 Y N_M0_d VDD VDD pmos_rvt L=2e-08 W=8.1e-08 nfin=3
M23 Y N_M0_d VDD VDD pmos_rvt L=2e-08 W=8.1e-08 nfin=3
M24 Y N_M0_d VDD VDD pmos_rvt L=2e-08 W=8.1e-08 nfin=3
M25 Y N_M0_d VDD VDD pmos_rvt L=2e-08 W=8.1e-08 nfin=3
M26 Y N_M0_d VDD VDD pmos_rvt L=2e-08 W=8.1e-08 nfin=3
M27 Y N_M0_d VDD VDD pmos_rvt L=2e-08 W=8.1e-08 nfin=3
.ENDS

.SUBCKT BUFx12f_ASAP7_75t_R A VDD VSS Y
M0 N_M0_d A VSS VSS nmos_rvt L=2e-08 W=8.1e-08 nfin=3
M1 N_M0_d A VSS VSS nmos_rvt L=2e-08 W=8.1e-08 nfin=3
M2 N_M0_d A VSS VSS nmos_rvt L=2e-08 W=8.1e-08 nfin=3
M3 N_M0_d A VSS VSS nmos_rvt L=2e-08 W=8.1e-08 nfin=3
M4 Y N_M0_d VSS VSS nmos_rvt L=2e-08 W=8.1e-08 nfin=3
M5 Y N_M0_d VSS VSS nmos_rvt L=2e-08 W=8.1e-08 nfin=3
M6 Y N_M0_d VSS VSS nmos_rvt L=2e-08 W=8.1e-08 nfin=3
M7 Y N_M0_d VSS VSS nmos_rvt L=2e-08 W=8.1e-08 nfin=3
M8 Y N_M0_d VSS VSS nmos_rvt L=2e-08 W=8.1e-08 nfin=3
M9 Y N_M0_d VSS VSS nmos_rvt L=2e-08 W=8.1e-08 nfin=3
M10 Y N_M0_d VSS VSS nmos_rvt L=2e-08 W=8.1e-08 nfin=3
M11 Y N_M0_d VSS VSS nmos_rvt L=2e-08 W=8.1e-08 nfin=3
M12 Y N_M0_d VSS VSS nmos_rvt L=2e-08 W=8.1e-08 nfin=3
M13 Y N_M0_d VSS VSS nmos_rvt L=2e-08 W=8.1e-08 nfin=3
M14 Y N_M0_d VSS VSS nmos_rvt L=2e-08 W=8.1e-08 nfin=3
M15 Y N_M0_d VSS VSS nmos_rvt L=2e-08 W=8.1e-08 nfin=3
M16 N_M0_d A VDD VDD pmos_rvt L=2e-08 W=8.1e-08 nfin=3
M17 N_M0_d A VDD VDD pmos_rvt L=2e-08 W=8.1e-08 nfin=3
M18 N_M0_d A VDD VDD pmos_rvt L=2e-08 W=8.1e-08 nfin=3
M19 N_M0_d A VDD VDD pmos_rvt L=2e-08 W=8.1e-08 nfin=3
M20 Y N_M0_d VDD VDD pmos_rvt L=2e-08 W=8.1e-08 nfin=3
M21 Y N_M0_d VDD VDD pmos_rvt L=2e-08 W=8.1e-08 nfin=3
M22 Y N_M0_d VDD VDD pmos_rvt L=2e-08 W=8.1e-08 nfin=3
M23 Y N_M0_d VDD VDD pmos_rvt L=2e-08 W=8.1e-08 nfin=3
M24 Y N_M0_d VDD VDD pmos_rvt L=2e-08 W=8.1e-08 nfin=3
M25 Y N_M0_d VDD VDD pmos_rvt L=2e-08 W=8.1e-08 nfin=3
M26 Y N_M0_d VDD VDD pmos_rvt L=2e-08 W=8.1e-08 nfin=3
M27 Y N_M0_d VDD VDD pmos_rvt L=2e-08 W=8.1e-08 nfin=3
M28 Y N_M0_d VDD VDD pmos_rvt L=2e-08 W=8.1e-08 nfin=3
M29 Y N_M0_d VDD VDD pmos_rvt L=2e-08 W=8.1e-08 nfin=3
M30 Y N_M0_d VDD VDD pmos_rvt L=2e-08 W=8.1e-08 nfin=3
M31 Y N_M0_d VDD VDD pmos_rvt L=2e-08 W=8.1e-08 nfin=3
.ENDS

.SUBCKT BUFx16f_ASAP7_75t_R A VDD VSS Y
M0 N_M0_d A VSS VSS nmos_rvt L=2e-08 W=8.1e-08 nfin=3
M1 N_M0_d A VSS VSS nmos_rvt L=2e-08 W=8.1e-08 nfin=3
M2 N_M0_d A VSS VSS nmos_rvt L=2e-08 W=8.1e-08 nfin=3
M3 N_M0_d A VSS VSS nmos_rvt L=2e-08 W=8.1e-08 nfin=3
M4 Y N_M0_d VSS VSS nmos_rvt L=2e-08 W=8.1e-08 nfin=3
M5 Y N_M0_d VSS VSS nmos_rvt L=2e-08 W=8.1e-08 nfin=3
M6 Y N_M0_d VSS VSS nmos_rvt L=2e-08 W=8.1e-08 nfin=3
M7 Y N_M0_d VSS VSS nmos_rvt L=2e-08 W=8.1e-08 nfin=3
M8 Y N_M0_d VSS VSS nmos_rvt L=2e-08 W=8.1e-08 nfin=3
M9 Y N_M0_d VSS VSS nmos_rvt L=2e-08 W=8.1e-08 nfin=3
M10 Y N_M0_d VSS VSS nmos_rvt L=2e-08 W=8.1e-08 nfin=3
M11 Y N_M0_d VSS VSS nmos_rvt L=2e-08 W=8.1e-08 nfin=3
M12 Y N_M0_d VSS VSS nmos_rvt L=2e-08 W=8.1e-08 nfin=3
M13 Y N_M0_d VSS VSS nmos_rvt L=2e-08 W=8.1e-08 nfin=3
M14 Y N_M0_d VSS VSS nmos_rvt L=2e-08 W=8.1e-08 nfin=3
M15 Y N_M0_d VSS VSS nmos_rvt L=2e-08 W=8.1e-08 nfin=3
M16 Y N_M0_d VSS VSS nmos_rvt L=2e-08 W=8.1e-08 nfin=3
M17 Y N_M0_d VSS VSS nmos_rvt L=2e-08 W=8.1e-08 nfin=3
M18 Y N_M0_d VSS VSS nmos_rvt L=2e-08 W=8.1e-08 nfin=3
M19 Y N_M0_d VSS VSS nmos_rvt L=2e-08 W=8.1e-08 nfin=3
M20 N_M0_d A VDD VDD pmos_rvt L=2e-08 W=8.1e-08 nfin=3
M21 N_M0_d A VDD VDD pmos_rvt L=2e-08 W=8.1e-08 nfin=3
M22 N_M0_d A VDD VDD pmos_rvt L=2e-08 W=8.1e-08 nfin=3
M23 N_M0_d A VDD VDD pmos_rvt L=2e-08 W=8.1e-08 nfin=3
M24 Y N_M0_d VDD VDD pmos_rvt L=2e-08 W=8.1e-08 nfin=3
M25 Y N_M0_d VDD VDD pmos_rvt L=2e-08 W=8.1e-08 nfin=3
M26 Y N_M0_d VDD VDD pmos_rvt L=2e-08 W=8.1e-08 nfin=3
M27 Y N_M0_d VDD VDD pmos_rvt L=2e-08 W=8.1e-08 nfin=3
M28 Y N_M0_d VDD VDD pmos_rvt L=2e-08 W=8.1e-08 nfin=3
M29 Y N_M0_d VDD VDD pmos_rvt L=2e-08 W=8.1e-08 nfin=3
M30 Y N_M0_d VDD VDD pmos_rvt L=2e-08 W=8.1e-08 nfin=3
M31 Y N_M0_d VDD VDD pmos_rvt L=2e-08 W=8.1e-08 nfin=3
M32 Y N_M0_d VDD VDD pmos_rvt L=2e-08 W=8.1e-08 nfin=3
M33 Y N_M0_d VDD VDD pmos_rvt L=2e-08 W=8.1e-08 nfin=3
M34 Y N_M0_d VDD VDD pmos_rvt L=2e-08 W=8.1e-08 nfin=3
M35 Y N_M0_d VDD VDD pmos_rvt L=2e-08 W=8.1e-08 nfin=3
M36 Y N_M0_d VDD VDD pmos_rvt L=2e-08 W=8.1e-08 nfin=3
M37 Y N_M0_d VDD VDD pmos_rvt L=2e-08 W=8.1e-08 nfin=3
M38 Y N_M0_d VDD VDD pmos_rvt L=2e-08 W=8.1e-08 nfin=3
M39 Y N_M0_d VDD VDD pmos_rvt L=2e-08 W=8.1e-08 nfin=3
.ENDS

.SUBCKT BUFx24_ASAP7_75t_R A VDD VSS Y
M0 N_M0_d A VSS VSS nmos_rvt L=2e-08 W=8.1e-08 nfin=3
M1 N_M0_d A VSS VSS nmos_rvt L=2e-08 W=8.1e-08 nfin=3
M2 N_M0_d A VSS VSS nmos_rvt L=2e-08 W=8.1e-08 nfin=3
M3 N_M0_d A VSS VSS nmos_rvt L=2e-08 W=8.1e-08 nfin=3
M4 Y N_M0_d VSS VSS nmos_rvt L=2e-08 W=8.1e-08 nfin=3
M5 Y N_M0_d VSS VSS nmos_rvt L=2e-08 W=8.1e-08 nfin=3
M6 Y N_M0_d VSS VSS nmos_rvt L=2e-08 W=8.1e-08 nfin=3
M7 Y N_M0_d VSS VSS nmos_rvt L=2e-08 W=8.1e-08 nfin=3
M8 Y N_M0_d VSS VSS nmos_rvt L=2e-08 W=8.1e-08 nfin=3
M9 Y N_M0_d VSS VSS nmos_rvt L=2e-08 W=8.1e-08 nfin=3
M10 Y N_M0_d VSS VSS nmos_rvt L=2e-08 W=8.1e-08 nfin=3
M11 Y N_M0_d VSS VSS nmos_rvt L=2e-08 W=8.1e-08 nfin=3
M12 Y N_M0_d VSS VSS nmos_rvt L=2e-08 W=8.1e-08 nfin=3
M13 Y N_M0_d VSS VSS nmos_rvt L=2e-08 W=8.1e-08 nfin=3
M14 Y N_M0_d VSS VSS nmos_rvt L=2e-08 W=8.1e-08 nfin=3
M15 Y N_M0_d VSS VSS nmos_rvt L=2e-08 W=8.1e-08 nfin=3
M16 Y N_M0_d VSS VSS nmos_rvt L=2e-08 W=8.1e-08 nfin=3
M17 Y N_M0_d VSS VSS nmos_rvt L=2e-08 W=8.1e-08 nfin=3
M18 Y N_M0_d VSS VSS nmos_rvt L=2e-08 W=8.1e-08 nfin=3
M19 Y N_M0_d VSS VSS nmos_rvt L=2e-08 W=8.1e-08 nfin=3
M20 Y N_M0_d VSS VSS nmos_rvt L=2e-08 W=8.1e-08 nfin=3
M21 Y N_M0_d VSS VSS nmos_rvt L=2e-08 W=8.1e-08 nfin=3
M22 Y N_M0_d VSS VSS nmos_rvt L=2e-08 W=8.1e-08 nfin=3
M23 Y N_M0_d VSS VSS nmos_rvt L=2e-08 W=8.1e-08 nfin=3
M24 Y N_M0_d VSS VSS nmos_rvt L=2e-08 W=8.1e-08 nfin=3
M25 Y N_M0_d VSS VSS nmos_rvt L=2e-08 W=8.1e-08 nfin=3
M26 Y N_M0_d VSS VSS nmos_rvt L=2e-08 W=8.1e-08 nfin=3
M27 Y N_M0_d VSS VSS nmos_rvt L=2e-08 W=8.1e-08 nfin=3
M28 N_M0_d A VDD VDD pmos_rvt L=2e-08 W=8.1e-08 nfin=3
M29 N_M0_d A VDD VDD pmos_rvt L=2e-08 W=8.1e-08 nfin=3
M30 N_M0_d A VDD VDD pmos_rvt L=2e-08 W=8.1e-08 nfin=3
M31 N_M0_d A VDD VDD pmos_rvt L=2e-08 W=8.1e-08 nfin=3
M32 Y N_M0_d VDD VDD pmos_rvt L=2e-08 W=8.1e-08 nfin=3
M33 Y N_M0_d VDD VDD pmos_rvt L=2e-08 W=8.1e-08 nfin=3
M34 Y N_M0_d VDD VDD pmos_rvt L=2e-08 W=8.1e-08 nfin=3
M35 Y N_M0_d VDD VDD pmos_rvt L=2e-08 W=8.1e-08 nfin=3
M36 Y N_M0_d VDD VDD pmos_rvt L=2e-08 W=8.1e-08 nfin=3
M37 Y N_M0_d VDD VDD pmos_rvt L=2e-08 W=8.1e-08 nfin=3
M38 Y N_M0_d VDD VDD pmos_rvt L=2e-08 W=8.1e-08 nfin=3
M39 Y N_M0_d VDD VDD pmos_rvt L=2e-08 W=8.1e-08 nfin=3
M40 Y N_M0_d VDD VDD pmos_rvt L=2e-08 W=8.1e-08 nfin=3
M41 Y N_M0_d VDD VDD pmos_rvt L=2e-08 W=8.1e-08 nfin=3
M42 Y N_M0_d VDD VDD pmos_rvt L=2e-08 W=8.1e-08 nfin=3
M43 Y N_M0_d VDD VDD pmos_rvt L=2e-08 W=8.1e-08 nfin=3
M44 Y N_M0_d VDD VDD pmos_rvt L=2e-08 W=8.1e-08 nfin=3
M45 Y N_M0_d VDD VDD pmos_rvt L=2e-08 W=8.1e-08 nfin=3
M46 Y N_M0_d VDD VDD pmos_rvt L=2e-08 W=8.1e-08 nfin=3
M47 Y N_M0_d VDD VDD pmos_rvt L=2e-08 W=8.1e-08 nfin=3
M48 Y N_M0_d VDD VDD pmos_rvt L=2e-08 W=8.1e-08 nfin=3
M49 Y N_M0_d VDD VDD pmos_rvt L=2e-08 W=8.1e-08 nfin=3
M50 Y N_M0_d VDD VDD pmos_rvt L=2e-08 W=8.1e-08 nfin=3
M51 Y N_M0_d VDD VDD pmos_rvt L=2e-08 W=8.1e-08 nfin=3
M52 Y N_M0_d VDD VDD pmos_rvt L=2e-08 W=8.1e-08 nfin=3
M53 Y N_M0_d VDD VDD pmos_rvt L=2e-08 W=8.1e-08 nfin=3
M54 Y N_M0_d VDD VDD pmos_rvt L=2e-08 W=8.1e-08 nfin=3
M55 Y N_M0_d VDD VDD pmos_rvt L=2e-08 W=8.1e-08 nfin=3
.ENDS

.SUBCKT BUFx2_ASAP7_75t_R A VDD VSS Y
M0 VSS A N_M0_s VSS nmos_rvt L=2e-08 W=5.4e-08 nfin=2
M1 Y N_M0_s VSS VSS nmos_rvt L=2e-08 W=8.1e-08 nfin=3
M2 Y N_M0_s VSS VSS nmos_rvt L=2e-08 W=8.1e-08 nfin=3
M3 VDD A N_M0_s VDD pmos_rvt L=2e-08 W=5.4e-08 nfin=2
M4 Y N_M0_s VDD VDD pmos_rvt L=2e-08 W=8.1e-08 nfin=3
M5 Y N_M0_s VDD VDD pmos_rvt L=2e-08 W=8.1e-08 nfin=3
.ENDS

.SUBCKT BUFx3_ASAP7_75t_R A VDD VSS Y
M0 VSS A N_M0_s VSS nmos_rvt L=2e-08 W=8.1e-08 nfin=3
M1 Y N_M0_s VSS VSS nmos_rvt L=2e-08 W=8.1e-08 nfin=3
M2 Y N_M0_s VSS VSS nmos_rvt L=2e-08 W=8.1e-08 nfin=3
M3 Y N_M0_s VSS VSS nmos_rvt L=2e-08 W=8.1e-08 nfin=3
M4 VDD A N_M0_s VDD pmos_rvt L=2e-08 W=8.1e-08 nfin=3
M5 Y N_M0_s VDD VDD pmos_rvt L=2e-08 W=8.1e-08 nfin=3
M6 Y N_M0_s VDD VDD pmos_rvt L=2e-08 W=8.1e-08 nfin=3
M7 Y N_M0_s VDD VDD pmos_rvt L=2e-08 W=8.1e-08 nfin=3
.ENDS

.SUBCKT BUFx4_ASAP7_75t_R A VDD VSS Y
M0 VSS A N_M0_s VSS nmos_rvt L=2e-08 W=5.4e-08 nfin=2
M1 Y N_M0_s VSS VSS nmos_rvt L=2e-08 W=8.1e-08 nfin=3
M2 Y N_M0_s VSS VSS nmos_rvt L=2e-08 W=8.1e-08 nfin=3
M3 Y N_M0_s VSS VSS nmos_rvt L=2e-08 W=8.1e-08 nfin=3
M4 Y N_M0_s VSS VSS nmos_rvt L=2e-08 W=8.1e-08 nfin=3
M5 VDD A N_M0_s VDD pmos_rvt L=2e-08 W=5.4e-08 nfin=2
M6 Y N_M0_s VDD VDD pmos_rvt L=2e-08 W=8.1e-08 nfin=3
M7 Y N_M0_s VDD VDD pmos_rvt L=2e-08 W=8.1e-08 nfin=3
M8 Y N_M0_s VDD VDD pmos_rvt L=2e-08 W=8.1e-08 nfin=3
M9 Y N_M0_s VDD VDD pmos_rvt L=2e-08 W=8.1e-08 nfin=3
.ENDS

.SUBCKT BUFx4f_ASAP7_75t_R A VDD VSS Y
M0 N_M0_d A VSS VSS nmos_rvt L=2e-08 W=2.7e-08 nfin=1
M1 N_M0_d A VSS VSS nmos_rvt L=2e-08 W=8.1e-08 nfin=3
M2 Y N_M0_d VSS VSS nmos_rvt L=2e-08 W=8.1e-08 nfin=3
M3 Y N_M0_d VSS VSS nmos_rvt L=2e-08 W=8.1e-08 nfin=3
M4 Y N_M0_d VSS VSS nmos_rvt L=2e-08 W=8.1e-08 nfin=3
M5 Y N_M0_d VSS VSS nmos_rvt L=2e-08 W=8.1e-08 nfin=3
M6 N_M0_d A VDD VDD pmos_rvt L=2e-08 W=2.7e-08 nfin=1
M7 N_M0_d A VDD VDD pmos_rvt L=2e-08 W=8.1e-08 nfin=3
M8 Y N_M0_d VDD VDD pmos_rvt L=2e-08 W=8.1e-08 nfin=3
M9 Y N_M0_d VDD VDD pmos_rvt L=2e-08 W=8.1e-08 nfin=3
M10 Y N_M0_d VDD VDD pmos_rvt L=2e-08 W=8.1e-08 nfin=3
M11 Y N_M0_d VDD VDD pmos_rvt L=2e-08 W=8.1e-08 nfin=3
.ENDS

.SUBCKT BUFx5_ASAP7_75t_R A VDD VSS Y
M0 VSS A N_M0_s VSS nmos_rvt L=2e-08 W=8.1e-08 nfin=3
M1 Y N_M0_s VSS VSS nmos_rvt L=2e-08 W=8.1e-08 nfin=3
M2 Y N_M0_s VSS VSS nmos_rvt L=2e-08 W=8.1e-08 nfin=3
M3 Y N_M0_s VSS VSS nmos_rvt L=2e-08 W=8.1e-08 nfin=3
M4 Y N_M0_s VSS VSS nmos_rvt L=2e-08 W=8.1e-08 nfin=3
M5 Y N_M0_s VSS VSS nmos_rvt L=2e-08 W=8.1e-08 nfin=3
M6 VDD A N_M0_s VDD pmos_rvt L=2e-08 W=8.1e-08 nfin=3
M7 Y N_M0_s VDD VDD pmos_rvt L=2e-08 W=8.1e-08 nfin=3
M8 Y N_M0_s VDD VDD pmos_rvt L=2e-08 W=8.1e-08 nfin=3
M9 Y N_M0_s VDD VDD pmos_rvt L=2e-08 W=8.1e-08 nfin=3
M10 Y N_M0_s VDD VDD pmos_rvt L=2e-08 W=8.1e-08 nfin=3
M11 Y N_M0_s VDD VDD pmos_rvt L=2e-08 W=8.1e-08 nfin=3
.ENDS

.SUBCKT BUFx6f_ASAP7_75t_R A VDD VSS Y
M0 N_M0_d A VSS VSS nmos_rvt L=2e-08 W=8.1e-08 nfin=3
M1 N_M0_d A VSS VSS nmos_rvt L=2e-08 W=8.1e-08 nfin=3
M2 Y N_M0_d VSS VSS nmos_rvt L=2e-08 W=8.1e-08 nfin=3
M3 Y N_M0_d VSS VSS nmos_rvt L=2e-08 W=8.1e-08 nfin=3
M4 Y N_M0_d VSS VSS nmos_rvt L=2e-08 W=8.1e-08 nfin=3
M5 Y N_M0_d VSS VSS nmos_rvt L=2e-08 W=8.1e-08 nfin=3
M6 Y N_M0_d VSS VSS nmos_rvt L=2e-08 W=8.1e-08 nfin=3
M7 Y N_M0_d VSS VSS nmos_rvt L=2e-08 W=8.1e-08 nfin=3
M8 N_M0_d A VDD VDD pmos_rvt L=2e-08 W=8.1e-08 nfin=3
M9 N_M0_d A VDD VDD pmos_rvt L=2e-08 W=8.1e-08 nfin=3
M10 Y N_M0_d VDD VDD pmos_rvt L=2e-08 W=8.1e-08 nfin=3
M11 Y N_M0_d VDD VDD pmos_rvt L=2e-08 W=8.1e-08 nfin=3
M12 Y N_M0_d VDD VDD pmos_rvt L=2e-08 W=8.1e-08 nfin=3
M13 Y N_M0_d VDD VDD pmos_rvt L=2e-08 W=8.1e-08 nfin=3
M14 Y N_M0_d VDD VDD pmos_rvt L=2e-08 W=8.1e-08 nfin=3
M15 Y N_M0_d VDD VDD pmos_rvt L=2e-08 W=8.1e-08 nfin=3
.ENDS

.SUBCKT BUFx8_ASAP7_75t_R A VDD VSS Y
M0 N_M0_d A VSS VSS nmos_rvt L=2e-08 W=5.4e-08 nfin=2
M1 N_M0_d A VSS VSS nmos_rvt L=2e-08 W=5.4e-08 nfin=2
M2 Y N_M0_d VSS VSS nmos_rvt L=2e-08 W=8.1e-08 nfin=3
M3 Y N_M0_d VSS VSS nmos_rvt L=2e-08 W=8.1e-08 nfin=3
M4 Y N_M0_d VSS VSS nmos_rvt L=2e-08 W=8.1e-08 nfin=3
M5 Y N_M0_d VSS VSS nmos_rvt L=2e-08 W=8.1e-08 nfin=3
M6 Y N_M0_d VSS VSS nmos_rvt L=2e-08 W=8.1e-08 nfin=3
M7 Y N_M0_d VSS VSS nmos_rvt L=2e-08 W=8.1e-08 nfin=3
M8 Y N_M0_d VSS VSS nmos_rvt L=2e-08 W=8.1e-08 nfin=3
M9 Y N_M0_d VSS VSS nmos_rvt L=2e-08 W=8.1e-08 nfin=3
M10 N_M0_d A VDD VDD pmos_rvt L=2e-08 W=5.4e-08 nfin=2
M11 N_M0_d A VDD VDD pmos_rvt L=2e-08 W=5.4e-08 nfin=2
M12 Y N_M0_d VDD VDD pmos_rvt L=2e-08 W=8.1e-08 nfin=3
M13 Y N_M0_d VDD VDD pmos_rvt L=2e-08 W=8.1e-08 nfin=3
M14 Y N_M0_d VDD VDD pmos_rvt L=2e-08 W=8.1e-08 nfin=3
M15 Y N_M0_d VDD VDD pmos_rvt L=2e-08 W=8.1e-08 nfin=3
M16 Y N_M0_d VDD VDD pmos_rvt L=2e-08 W=8.1e-08 nfin=3
M17 Y N_M0_d VDD VDD pmos_rvt L=2e-08 W=8.1e-08 nfin=3
M18 Y N_M0_d VDD VDD pmos_rvt L=2e-08 W=8.1e-08 nfin=3
M19 Y N_M0_d VDD VDD pmos_rvt L=2e-08 W=8.1e-08 nfin=3
.ENDS

.SUBCKT CKINVDCx10_ASAP7_75t_R A VDD VSS Y
M0 Y A VSS VSS nmos_rvt L=2e-08 W=8.1e-08 nfin=3
M1 Y A VSS VSS nmos_rvt L=2e-08 W=8.1e-08 nfin=3
M16 N_M16_d N_M16_d VSS VSS nmos_rvt L=2e-08 W=8.1e-08 nfin=3
M17 N_M16_d N_M16_d VSS VSS nmos_rvt L=2e-08 W=8.1e-08 nfin=3
M14 N_M16_d N_M14_g VSS VSS nmos_rvt L=2e-08 W=8.1e-08 nfin=3
M15 N_M16_d N_M14_g VSS VSS nmos_rvt L=2e-08 W=8.1e-08 nfin=3
M6 Y A VSS VSS nmos_rvt L=2e-08 W=8.1e-08 nfin=3
M7 Y A VSS VSS nmos_rvt L=2e-08 W=8.1e-08 nfin=3
M8 N_M8_d N_M8_d VSS VSS nmos_rvt L=2e-08 W=8.1e-08 nfin=3
M9 N_M8_d N_M8_d VSS VSS nmos_rvt L=2e-08 W=8.1e-08 nfin=3
M10 N_M8_d N_M10_g VSS VSS nmos_rvt L=2e-08 W=8.1e-08 nfin=3
M11 N_M8_d N_M10_g VSS VSS nmos_rvt L=2e-08 W=8.1e-08 nfin=3
M12 Y A VSS VSS nmos_rvt L=2e-08 W=8.1e-08 nfin=3
M13 Y A VSS VSS nmos_rvt L=2e-08 W=8.1e-08 nfin=3
M4 N_M4_d N_M4_g VSS VSS nmos_rvt L=2e-08 W=8.1e-08 nfin=3
M5 N_M4_d N_M4_g VSS VSS nmos_rvt L=2e-08 W=8.1e-08 nfin=3
M2 N_M4_d N_M4_d VSS VSS nmos_rvt L=2e-08 W=8.1e-08 nfin=3
M3 N_M4_d N_M4_d VSS VSS nmos_rvt L=2e-08 W=8.1e-08 nfin=3
M18 Y A VSS VSS nmos_rvt L=2e-08 W=8.1e-08 nfin=3
M19 Y A VSS VSS nmos_rvt L=2e-08 W=8.1e-08 nfin=3
M20 Y A VSS VSS nmos_rvt L=2e-08 W=8.1e-08 nfin=3
M21 Y A VSS VSS nmos_rvt L=2e-08 W=8.1e-08 nfin=3
M22 Y A VDD VDD pmos_rvt L=2e-08 W=8.1e-08 nfin=3
M23 Y A VDD VDD pmos_rvt L=2e-08 W=8.1e-08 nfin=3
M38 N_M14_g N_M16_d VDD VDD pmos_rvt L=2e-08 W=8.1e-08 nfin=3
M39 N_M14_g N_M16_d VDD VDD pmos_rvt L=2e-08 W=8.1e-08 nfin=3
M36 N_M14_g N_M14_g VDD VDD pmos_rvt L=2e-08 W=8.1e-08 nfin=3
M37 N_M14_g N_M14_g VDD VDD pmos_rvt L=2e-08 W=8.1e-08 nfin=3
M28 Y A VDD VDD pmos_rvt L=2e-08 W=8.1e-08 nfin=3
M29 Y A VDD VDD pmos_rvt L=2e-08 W=8.1e-08 nfin=3
M30 N_M10_g N_M8_d VDD VDD pmos_rvt L=2e-08 W=8.1e-08 nfin=3
M31 N_M10_g N_M8_d VDD VDD pmos_rvt L=2e-08 W=8.1e-08 nfin=3
M32 N_M10_g N_M10_g VDD VDD pmos_rvt L=2e-08 W=8.1e-08 nfin=3
M33 N_M10_g N_M10_g VDD VDD pmos_rvt L=2e-08 W=8.1e-08 nfin=3
M34 Y A VDD VDD pmos_rvt L=2e-08 W=8.1e-08 nfin=3
M35 Y A VDD VDD pmos_rvt L=2e-08 W=8.1e-08 nfin=3
M26 N_M4_g N_M4_g VDD VDD pmos_rvt L=2e-08 W=8.1e-08 nfin=3
M27 N_M4_g N_M4_g VDD VDD pmos_rvt L=2e-08 W=8.1e-08 nfin=3
M24 N_M4_g N_M4_d VDD VDD pmos_rvt L=2e-08 W=8.1e-08 nfin=3
M25 N_M4_g N_M4_d VDD VDD pmos_rvt L=2e-08 W=8.1e-08 nfin=3
M40 Y A VDD VDD pmos_rvt L=2e-08 W=8.1e-08 nfin=3
M41 Y A VDD VDD pmos_rvt L=2e-08 W=8.1e-08 nfin=3
M42 Y A VDD VDD pmos_rvt L=2e-08 W=8.1e-08 nfin=3
M43 Y A VDD VDD pmos_rvt L=2e-08 W=8.1e-08 nfin=3
.ENDS

.SUBCKT CKINVDCx11_ASAP7_75t_R A VDD VSS Y
M0 Y A VSS VSS nmos_rvt L=2e-08 W=8.1e-08 nfin=3
M1 Y A VSS VSS nmos_rvt L=2e-08 W=8.1e-08 nfin=3
M20 N_M20_d N_M20_d VSS VSS nmos_rvt L=2e-08 W=8.1e-08 nfin=3
M21 N_M20_d N_M20_d VSS VSS nmos_rvt L=2e-08 W=8.1e-08 nfin=3
M18 N_M20_d N_M18_g VSS VSS nmos_rvt L=2e-08 W=8.1e-08 nfin=3
M19 N_M20_d N_M18_g VSS VSS nmos_rvt L=2e-08 W=8.1e-08 nfin=3
M6 Y A VSS VSS nmos_rvt L=2e-08 W=5.4e-08 nfin=2
M7 Y A VSS VSS nmos_rvt L=2e-08 W=5.4e-08 nfin=2
M8 Y A VSS VSS nmos_rvt L=2e-08 W=5.4e-08 nfin=2
M9 Y A VSS VSS nmos_rvt L=2e-08 W=8.1e-08 nfin=3
M10 N_M10_d N_M10_d VSS VSS nmos_rvt L=2e-08 W=8.1e-08 nfin=3
M11 N_M10_d N_M10_d VSS VSS nmos_rvt L=2e-08 W=8.1e-08 nfin=3
M12 N_M10_d N_M12_g VSS VSS nmos_rvt L=2e-08 W=8.1e-08 nfin=3
M13 N_M10_d N_M12_g VSS VSS nmos_rvt L=2e-08 W=8.1e-08 nfin=3
M14 Y A VSS VSS nmos_rvt L=2e-08 W=8.1e-08 nfin=3
M15 Y A VSS VSS nmos_rvt L=2e-08 W=8.1e-08 nfin=3
M16 Y A VSS VSS nmos_rvt L=2e-08 W=8.1e-08 nfin=3
M17 Y A VSS VSS nmos_rvt L=2e-08 W=8.1e-08 nfin=3
M4 N_M4_d N_M4_g VSS VSS nmos_rvt L=2e-08 W=8.1e-08 nfin=3
M5 N_M4_d N_M4_g VSS VSS nmos_rvt L=2e-08 W=8.1e-08 nfin=3
M2 N_M4_d N_M4_d VSS VSS nmos_rvt L=2e-08 W=8.1e-08 nfin=3
M3 N_M4_d N_M4_d VSS VSS nmos_rvt L=2e-08 W=8.1e-08 nfin=3
M22 Y A VSS VSS nmos_rvt L=2e-08 W=8.1e-08 nfin=3
M23 Y A VSS VSS nmos_rvt L=2e-08 W=8.1e-08 nfin=3
M24 Y A VDD VDD pmos_rvt L=2e-08 W=8.1e-08 nfin=3
M25 Y A VDD VDD pmos_rvt L=2e-08 W=8.1e-08 nfin=3
M44 N_M18_g N_M20_d VDD VDD pmos_rvt L=2e-08 W=8.1e-08 nfin=3
M45 N_M18_g N_M20_d VDD VDD pmos_rvt L=2e-08 W=8.1e-08 nfin=3
M42 N_M18_g N_M18_g VDD VDD pmos_rvt L=2e-08 W=8.1e-08 nfin=3
M43 N_M18_g N_M18_g VDD VDD pmos_rvt L=2e-08 W=8.1e-08 nfin=3
M30 Y A VDD VDD pmos_rvt L=2e-08 W=5.4e-08 nfin=2
M31 Y A VDD VDD pmos_rvt L=2e-08 W=5.4e-08 nfin=2
M32 Y A VDD VDD pmos_rvt L=2e-08 W=5.4e-08 nfin=2
M33 Y A VDD VDD pmos_rvt L=2e-08 W=8.1e-08 nfin=3
M34 N_M12_g N_M10_d VDD VDD pmos_rvt L=2e-08 W=8.1e-08 nfin=3
M35 N_M12_g N_M10_d VDD VDD pmos_rvt L=2e-08 W=8.1e-08 nfin=3
M36 N_M12_g N_M12_g VDD VDD pmos_rvt L=2e-08 W=8.1e-08 nfin=3
M37 N_M12_g N_M12_g VDD VDD pmos_rvt L=2e-08 W=8.1e-08 nfin=3
M38 Y A VDD VDD pmos_rvt L=2e-08 W=8.1e-08 nfin=3
M39 Y A VDD VDD pmos_rvt L=2e-08 W=8.1e-08 nfin=3
M40 Y A VDD VDD pmos_rvt L=2e-08 W=8.1e-08 nfin=3
M41 Y A VDD VDD pmos_rvt L=2e-08 W=8.1e-08 nfin=3
M28 N_M4_g N_M4_g VDD VDD pmos_rvt L=2e-08 W=8.1e-08 nfin=3
M29 N_M4_g N_M4_g VDD VDD pmos_rvt L=2e-08 W=8.1e-08 nfin=3
M26 N_M4_g N_M4_d VDD VDD pmos_rvt L=2e-08 W=8.1e-08 nfin=3
M27 N_M4_g N_M4_d VDD VDD pmos_rvt L=2e-08 W=8.1e-08 nfin=3
M46 Y A VDD VDD pmos_rvt L=2e-08 W=8.1e-08 nfin=3
M47 Y A VDD VDD pmos_rvt L=2e-08 W=8.1e-08 nfin=3
.ENDS

.SUBCKT CKINVDCx12_ASAP7_75t_R A VDD VSS Y
M0 Y A VSS VSS nmos_rvt L=2e-08 W=8.1e-08 nfin=3
M1 Y A VSS VSS nmos_rvt L=2e-08 W=8.1e-08 nfin=3
M20 N_M20_d N_M20_d VSS VSS nmos_rvt L=2e-08 W=8.1e-08 nfin=3
M21 N_M20_d N_M20_d VSS VSS nmos_rvt L=2e-08 W=8.1e-08 nfin=3
M18 N_M20_d N_M18_g VSS VSS nmos_rvt L=2e-08 W=8.1e-08 nfin=3
M19 N_M20_d N_M18_g VSS VSS nmos_rvt L=2e-08 W=8.1e-08 nfin=3
M6 Y A VSS VSS nmos_rvt L=2e-08 W=8.1e-08 nfin=3
M7 Y A VSS VSS nmos_rvt L=2e-08 W=8.1e-08 nfin=3
M8 Y A VSS VSS nmos_rvt L=2e-08 W=8.1e-08 nfin=3
M9 Y A VSS VSS nmos_rvt L=2e-08 W=8.1e-08 nfin=3
M10 N_M10_d N_M10_d VSS VSS nmos_rvt L=2e-08 W=8.1e-08 nfin=3
M11 N_M10_d N_M10_d VSS VSS nmos_rvt L=2e-08 W=8.1e-08 nfin=3
M12 N_M10_d N_M12_g VSS VSS nmos_rvt L=2e-08 W=8.1e-08 nfin=3
M13 N_M10_d N_M12_g VSS VSS nmos_rvt L=2e-08 W=8.1e-08 nfin=3
M14 Y A VSS VSS nmos_rvt L=2e-08 W=8.1e-08 nfin=3
M15 Y A VSS VSS nmos_rvt L=2e-08 W=8.1e-08 nfin=3
M16 Y A VSS VSS nmos_rvt L=2e-08 W=8.1e-08 nfin=3
M17 Y A VSS VSS nmos_rvt L=2e-08 W=8.1e-08 nfin=3
M4 N_M4_d N_M4_g VSS VSS nmos_rvt L=2e-08 W=8.1e-08 nfin=3
M5 N_M4_d N_M4_g VSS VSS nmos_rvt L=2e-08 W=8.1e-08 nfin=3
M2 N_M4_d N_M4_d VSS VSS nmos_rvt L=2e-08 W=8.1e-08 nfin=3
M3 N_M4_d N_M4_d VSS VSS nmos_rvt L=2e-08 W=8.1e-08 nfin=3
M22 Y A VSS VSS nmos_rvt L=2e-08 W=8.1e-08 nfin=3
M23 Y A VSS VSS nmos_rvt L=2e-08 W=8.1e-08 nfin=3
M24 Y A VDD VDD pmos_rvt L=2e-08 W=8.1e-08 nfin=3
M25 Y A VDD VDD pmos_rvt L=2e-08 W=8.1e-08 nfin=3
M44 N_M18_g N_M20_d VDD VDD pmos_rvt L=2e-08 W=8.1e-08 nfin=3
M45 N_M18_g N_M20_d VDD VDD pmos_rvt L=2e-08 W=8.1e-08 nfin=3
M42 N_M18_g N_M18_g VDD VDD pmos_rvt L=2e-08 W=8.1e-08 nfin=3
M43 N_M18_g N_M18_g VDD VDD pmos_rvt L=2e-08 W=8.1e-08 nfin=3
M30 Y A VDD VDD pmos_rvt L=2e-08 W=8.1e-08 nfin=3
M31 Y A VDD VDD pmos_rvt L=2e-08 W=8.1e-08 nfin=3
M32 Y A VDD VDD pmos_rvt L=2e-08 W=8.1e-08 nfin=3
M33 Y A VDD VDD pmos_rvt L=2e-08 W=8.1e-08 nfin=3
M34 N_M12_g N_M10_d VDD VDD pmos_rvt L=2e-08 W=8.1e-08 nfin=3
M35 N_M12_g N_M10_d VDD VDD pmos_rvt L=2e-08 W=8.1e-08 nfin=3
M36 N_M12_g N_M12_g VDD VDD pmos_rvt L=2e-08 W=8.1e-08 nfin=3
M37 N_M12_g N_M12_g VDD VDD pmos_rvt L=2e-08 W=8.1e-08 nfin=3
M38 Y A VDD VDD pmos_rvt L=2e-08 W=8.1e-08 nfin=3
M39 Y A VDD VDD pmos_rvt L=2e-08 W=8.1e-08 nfin=3
M40 Y A VDD VDD pmos_rvt L=2e-08 W=8.1e-08 nfin=3
M41 Y A VDD VDD pmos_rvt L=2e-08 W=8.1e-08 nfin=3
M28 N_M4_g N_M4_g VDD VDD pmos_rvt L=2e-08 W=8.1e-08 nfin=3
M29 N_M4_g N_M4_g VDD VDD pmos_rvt L=2e-08 W=8.1e-08 nfin=3
M26 N_M4_g N_M4_d VDD VDD pmos_rvt L=2e-08 W=8.1e-08 nfin=3
M27 N_M4_g N_M4_d VDD VDD pmos_rvt L=2e-08 W=8.1e-08 nfin=3
M46 Y A VDD VDD pmos_rvt L=2e-08 W=8.1e-08 nfin=3
M47 Y A VDD VDD pmos_rvt L=2e-08 W=8.1e-08 nfin=3
.ENDS

.SUBCKT CKINVDCx14_ASAP7_75t_R A VDD VSS Y
M0 Y A VSS VSS nmos_rvt L=2e-08 W=8.1e-08 nfin=3
M1 Y A VSS VSS nmos_rvt L=2e-08 W=8.1e-08 nfin=3
M20 N_M20_d N_M20_d VSS VSS nmos_rvt L=2e-08 W=8.1e-08 nfin=3
M21 N_M20_d N_M20_d VSS VSS nmos_rvt L=2e-08 W=8.1e-08 nfin=3
M18 N_M20_d N_M18_g VSS VSS nmos_rvt L=2e-08 W=8.1e-08 nfin=3
M19 N_M20_d N_M18_g VSS VSS nmos_rvt L=2e-08 W=8.1e-08 nfin=3
M6 Y A VSS VSS nmos_rvt L=2e-08 W=8.1e-08 nfin=3
M7 Y A VSS VSS nmos_rvt L=2e-08 W=8.1e-08 nfin=3
M8 Y A VSS VSS nmos_rvt L=2e-08 W=8.1e-08 nfin=3
M9 Y A VSS VSS nmos_rvt L=2e-08 W=8.1e-08 nfin=3
M10 N_M10_d N_M10_d VSS VSS nmos_rvt L=2e-08 W=8.1e-08 nfin=3
M11 N_M10_d N_M10_d VSS VSS nmos_rvt L=2e-08 W=8.1e-08 nfin=3
M12 N_M10_d N_M12_g VSS VSS nmos_rvt L=2e-08 W=8.1e-08 nfin=3
M13 N_M10_d N_M12_g VSS VSS nmos_rvt L=2e-08 W=8.1e-08 nfin=3
M14 Y A VSS VSS nmos_rvt L=2e-08 W=8.1e-08 nfin=3
M15 Y A VSS VSS nmos_rvt L=2e-08 W=8.1e-08 nfin=3
M16 Y A VSS VSS nmos_rvt L=2e-08 W=8.1e-08 nfin=3
M17 Y A VSS VSS nmos_rvt L=2e-08 W=8.1e-08 nfin=3
M4 N_M4_d N_M4_g VSS VSS nmos_rvt L=2e-08 W=8.1e-08 nfin=3
M5 N_M4_d N_M4_g VSS VSS nmos_rvt L=2e-08 W=8.1e-08 nfin=3
M2 N_M4_d N_M4_d VSS VSS nmos_rvt L=2e-08 W=8.1e-08 nfin=3
M3 N_M4_d N_M4_d VSS VSS nmos_rvt L=2e-08 W=8.1e-08 nfin=3
M22 Y A VSS VSS nmos_rvt L=2e-08 W=8.1e-08 nfin=3
M23 Y A VSS VSS nmos_rvt L=2e-08 W=8.1e-08 nfin=3
M24 Y A VSS VSS nmos_rvt L=2e-08 W=8.1e-08 nfin=3
M25 Y A VSS VSS nmos_rvt L=2e-08 W=8.1e-08 nfin=3
M26 Y A VDD VDD pmos_rvt L=2e-08 W=8.1e-08 nfin=3
M27 Y A VDD VDD pmos_rvt L=2e-08 W=8.1e-08 nfin=3
M46 N_M18_g N_M20_d VDD VDD pmos_rvt L=2e-08 W=8.1e-08 nfin=3
M47 N_M18_g N_M20_d VDD VDD pmos_rvt L=2e-08 W=8.1e-08 nfin=3
M44 N_M18_g N_M18_g VDD VDD pmos_rvt L=2e-08 W=8.1e-08 nfin=3
M45 N_M18_g N_M18_g VDD VDD pmos_rvt L=2e-08 W=8.1e-08 nfin=3
M32 Y A VDD VDD pmos_rvt L=2e-08 W=8.1e-08 nfin=3
M33 Y A VDD VDD pmos_rvt L=2e-08 W=8.1e-08 nfin=3
M34 Y A VDD VDD pmos_rvt L=2e-08 W=8.1e-08 nfin=3
M35 Y A VDD VDD pmos_rvt L=2e-08 W=8.1e-08 nfin=3
M36 N_M12_g N_M10_d VDD VDD pmos_rvt L=2e-08 W=8.1e-08 nfin=3
M37 N_M12_g N_M10_d VDD VDD pmos_rvt L=2e-08 W=8.1e-08 nfin=3
M38 N_M12_g N_M12_g VDD VDD pmos_rvt L=2e-08 W=8.1e-08 nfin=3
M39 N_M12_g N_M12_g VDD VDD pmos_rvt L=2e-08 W=8.1e-08 nfin=3
M40 Y A VDD VDD pmos_rvt L=2e-08 W=8.1e-08 nfin=3
M41 Y A VDD VDD pmos_rvt L=2e-08 W=8.1e-08 nfin=3
M42 Y A VDD VDD pmos_rvt L=2e-08 W=8.1e-08 nfin=3
M43 Y A VDD VDD pmos_rvt L=2e-08 W=8.1e-08 nfin=3
M30 N_M4_g N_M4_g VDD VDD pmos_rvt L=2e-08 W=8.1e-08 nfin=3
M31 N_M4_g N_M4_g VDD VDD pmos_rvt L=2e-08 W=8.1e-08 nfin=3
M28 N_M4_g N_M4_d VDD VDD pmos_rvt L=2e-08 W=8.1e-08 nfin=3
M29 N_M4_g N_M4_d VDD VDD pmos_rvt L=2e-08 W=8.1e-08 nfin=3
M48 Y A VDD VDD pmos_rvt L=2e-08 W=8.1e-08 nfin=3
M49 Y A VDD VDD pmos_rvt L=2e-08 W=8.1e-08 nfin=3
M50 Y A VDD VDD pmos_rvt L=2e-08 W=8.1e-08 nfin=3
M51 Y A VDD VDD pmos_rvt L=2e-08 W=8.1e-08 nfin=3
.ENDS

.SUBCKT CKINVDCx16_ASAP7_75t_R A VDD VSS Y
M0 Y A VSS VSS nmos_rvt L=2e-08 W=8.1e-08 nfin=3
M1 Y A VSS VSS nmos_rvt L=2e-08 W=8.1e-08 nfin=3
M2 Y A VSS VSS nmos_rvt L=2e-08 W=8.1e-08 nfin=3
M3 Y A VSS VSS nmos_rvt L=2e-08 W=8.1e-08 nfin=3
M22 N_M22_d N_M22_d VSS VSS nmos_rvt L=2e-08 W=8.1e-08 nfin=3
M23 N_M22_d N_M22_d VSS VSS nmos_rvt L=2e-08 W=8.1e-08 nfin=3
M20 N_M22_d N_M20_g VSS VSS nmos_rvt L=2e-08 W=8.1e-08 nfin=3
M21 N_M22_d N_M20_g VSS VSS nmos_rvt L=2e-08 W=8.1e-08 nfin=3
M8 Y A VSS VSS nmos_rvt L=2e-08 W=8.1e-08 nfin=3
M9 Y A VSS VSS nmos_rvt L=2e-08 W=8.1e-08 nfin=3
M10 Y A VSS VSS nmos_rvt L=2e-08 W=8.1e-08 nfin=3
M11 Y A VSS VSS nmos_rvt L=2e-08 W=8.1e-08 nfin=3
M12 N_M12_d N_M12_d VSS VSS nmos_rvt L=2e-08 W=8.1e-08 nfin=3
M13 N_M12_d N_M12_d VSS VSS nmos_rvt L=2e-08 W=8.1e-08 nfin=3
M14 N_M12_d N_M14_g VSS VSS nmos_rvt L=2e-08 W=8.1e-08 nfin=3
M15 N_M12_d N_M14_g VSS VSS nmos_rvt L=2e-08 W=8.1e-08 nfin=3
M16 Y A VSS VSS nmos_rvt L=2e-08 W=8.1e-08 nfin=3
M17 Y A VSS VSS nmos_rvt L=2e-08 W=8.1e-08 nfin=3
M18 Y A VSS VSS nmos_rvt L=2e-08 W=8.1e-08 nfin=3
M19 Y A VSS VSS nmos_rvt L=2e-08 W=8.1e-08 nfin=3
M6 N_M6_d N_M6_g VSS VSS nmos_rvt L=2e-08 W=8.1e-08 nfin=3
M7 N_M6_d N_M6_g VSS VSS nmos_rvt L=2e-08 W=8.1e-08 nfin=3
M4 N_M6_d N_M6_d VSS VSS nmos_rvt L=2e-08 W=8.1e-08 nfin=3
M5 N_M6_d N_M6_d VSS VSS nmos_rvt L=2e-08 W=8.1e-08 nfin=3
M24 Y A VSS VSS nmos_rvt L=2e-08 W=8.1e-08 nfin=3
M25 Y A VSS VSS nmos_rvt L=2e-08 W=8.1e-08 nfin=3
M26 Y A VSS VSS nmos_rvt L=2e-08 W=8.1e-08 nfin=3
M27 Y A VSS VSS nmos_rvt L=2e-08 W=8.1e-08 nfin=3
M28 Y A VDD VDD pmos_rvt L=2e-08 W=8.1e-08 nfin=3
M29 Y A VDD VDD pmos_rvt L=2e-08 W=8.1e-08 nfin=3
M30 Y A VDD VDD pmos_rvt L=2e-08 W=8.1e-08 nfin=3
M31 Y A VDD VDD pmos_rvt L=2e-08 W=8.1e-08 nfin=3
M50 N_M20_g N_M22_d VDD VDD pmos_rvt L=2e-08 W=8.1e-08 nfin=3
M51 N_M20_g N_M22_d VDD VDD pmos_rvt L=2e-08 W=8.1e-08 nfin=3
M48 N_M20_g N_M20_g VDD VDD pmos_rvt L=2e-08 W=8.1e-08 nfin=3
M49 N_M20_g N_M20_g VDD VDD pmos_rvt L=2e-08 W=8.1e-08 nfin=3
M36 Y A VDD VDD pmos_rvt L=2e-08 W=8.1e-08 nfin=3
M37 Y A VDD VDD pmos_rvt L=2e-08 W=8.1e-08 nfin=3
M38 Y A VDD VDD pmos_rvt L=2e-08 W=8.1e-08 nfin=3
M39 Y A VDD VDD pmos_rvt L=2e-08 W=8.1e-08 nfin=3
M40 N_M14_g N_M12_d VDD VDD pmos_rvt L=2e-08 W=8.1e-08 nfin=3
M41 N_M14_g N_M12_d VDD VDD pmos_rvt L=2e-08 W=8.1e-08 nfin=3
M42 N_M14_g N_M14_g VDD VDD pmos_rvt L=2e-08 W=8.1e-08 nfin=3
M43 N_M14_g N_M14_g VDD VDD pmos_rvt L=2e-08 W=8.1e-08 nfin=3
M44 Y A VDD VDD pmos_rvt L=2e-08 W=8.1e-08 nfin=3
M45 Y A VDD VDD pmos_rvt L=2e-08 W=8.1e-08 nfin=3
M46 Y A VDD VDD pmos_rvt L=2e-08 W=8.1e-08 nfin=3
M47 Y A VDD VDD pmos_rvt L=2e-08 W=8.1e-08 nfin=3
M34 N_M6_g N_M6_g VDD VDD pmos_rvt L=2e-08 W=8.1e-08 nfin=3
M35 N_M6_g N_M6_g VDD VDD pmos_rvt L=2e-08 W=8.1e-08 nfin=3
M32 N_M6_g N_M6_d VDD VDD pmos_rvt L=2e-08 W=8.1e-08 nfin=3
M33 N_M6_g N_M6_d VDD VDD pmos_rvt L=2e-08 W=8.1e-08 nfin=3
M52 Y A VDD VDD pmos_rvt L=2e-08 W=8.1e-08 nfin=3
M53 Y A VDD VDD pmos_rvt L=2e-08 W=8.1e-08 nfin=3
M54 Y A VDD VDD pmos_rvt L=2e-08 W=8.1e-08 nfin=3
M55 Y A VDD VDD pmos_rvt L=2e-08 W=8.1e-08 nfin=3
.ENDS

.SUBCKT CKINVDCx20_ASAP7_75t_R A VDD VSS Y
M0 Y A VSS VSS nmos_rvt L=2e-08 W=8.1e-08 nfin=3
M1 Y A VSS VSS nmos_rvt L=2e-08 W=8.1e-08 nfin=3
M2 Y A VSS VSS nmos_rvt L=2e-08 W=8.1e-08 nfin=3
M3 Y A VSS VSS nmos_rvt L=2e-08 W=8.1e-08 nfin=3
M4 N_M4_d N_M4_d VSS VSS nmos_rvt L=2e-08 W=8.1e-08 nfin=3
M5 N_M4_d N_M4_d VSS VSS nmos_rvt L=2e-08 W=8.1e-08 nfin=3
M6 N_M4_d N_M6_g VSS VSS nmos_rvt L=2e-08 W=8.1e-08 nfin=3
M7 N_M4_d N_M6_g VSS VSS nmos_rvt L=2e-08 W=8.1e-08 nfin=3
M8 Y A VSS VSS nmos_rvt L=2e-08 W=8.1e-08 nfin=3
M9 Y A VSS VSS nmos_rvt L=2e-08 W=8.1e-08 nfin=3
M10 Y A VSS VSS nmos_rvt L=2e-08 W=8.1e-08 nfin=3
M11 Y A VSS VSS nmos_rvt L=2e-08 W=8.1e-08 nfin=3
M12 N_M12_d N_M12_d VSS VSS nmos_rvt L=2e-08 W=8.1e-08 nfin=3
M13 N_M12_d N_M12_d VSS VSS nmos_rvt L=2e-08 W=8.1e-08 nfin=3
M14 N_M12_d N_M14_g VSS VSS nmos_rvt L=2e-08 W=8.1e-08 nfin=3
M15 N_M12_d N_M14_g VSS VSS nmos_rvt L=2e-08 W=8.1e-08 nfin=3
M16 Y A VSS VSS nmos_rvt L=2e-08 W=8.1e-08 nfin=3
M17 Y A VSS VSS nmos_rvt L=2e-08 W=8.1e-08 nfin=3
M18 Y A VSS VSS nmos_rvt L=2e-08 W=8.1e-08 nfin=3
M19 Y A VSS VSS nmos_rvt L=2e-08 W=8.1e-08 nfin=3
M28 N_M28_d N_M28_g VSS VSS nmos_rvt L=2e-08 W=8.1e-08 nfin=3
M29 N_M28_d N_M28_g VSS VSS nmos_rvt L=2e-08 W=8.1e-08 nfin=3
M30 N_M28_d N_M28_d VSS VSS nmos_rvt L=2e-08 W=8.1e-08 nfin=3
M31 N_M28_d N_M28_d VSS VSS nmos_rvt L=2e-08 W=8.1e-08 nfin=3
M24 Y A VSS VSS nmos_rvt L=2e-08 W=8.1e-08 nfin=3
M25 Y A VSS VSS nmos_rvt L=2e-08 W=8.1e-08 nfin=3
M26 Y A VSS VSS nmos_rvt L=2e-08 W=8.1e-08 nfin=3
M27 Y A VSS VSS nmos_rvt L=2e-08 W=8.1e-08 nfin=3
M20 N_M20_d N_M20_g VSS VSS nmos_rvt L=2e-08 W=8.1e-08 nfin=3
M21 N_M20_d N_M20_g VSS VSS nmos_rvt L=2e-08 W=8.1e-08 nfin=3
M22 N_M20_d N_M20_d VSS VSS nmos_rvt L=2e-08 W=8.1e-08 nfin=3
M23 N_M20_d N_M20_d VSS VSS nmos_rvt L=2e-08 W=8.1e-08 nfin=3
M32 Y A VSS VSS nmos_rvt L=2e-08 W=8.1e-08 nfin=3
M33 Y A VSS VSS nmos_rvt L=2e-08 W=8.1e-08 nfin=3
M34 Y A VSS VSS nmos_rvt L=2e-08 W=8.1e-08 nfin=3
M35 Y A VSS VSS nmos_rvt L=2e-08 W=8.1e-08 nfin=3
M36 Y A VDD VDD pmos_rvt L=2e-08 W=8.1e-08 nfin=3
M37 Y A VDD VDD pmos_rvt L=2e-08 W=8.1e-08 nfin=3
M38 Y A VDD VDD pmos_rvt L=2e-08 W=8.1e-08 nfin=3
M39 Y A VDD VDD pmos_rvt L=2e-08 W=8.1e-08 nfin=3
M40 N_M6_g N_M4_d VDD VDD pmos_rvt L=2e-08 W=8.1e-08 nfin=3
M41 N_M6_g N_M4_d VDD VDD pmos_rvt L=2e-08 W=8.1e-08 nfin=3
M42 N_M6_g N_M6_g VDD VDD pmos_rvt L=2e-08 W=8.1e-08 nfin=3
M43 N_M6_g N_M6_g VDD VDD pmos_rvt L=2e-08 W=8.1e-08 nfin=3
M44 Y A VDD VDD pmos_rvt L=2e-08 W=8.1e-08 nfin=3
M45 Y A VDD VDD pmos_rvt L=2e-08 W=8.1e-08 nfin=3
M46 Y A VDD VDD pmos_rvt L=2e-08 W=8.1e-08 nfin=3
M47 Y A VDD VDD pmos_rvt L=2e-08 W=8.1e-08 nfin=3
M48 N_M14_g N_M12_d VDD VDD pmos_rvt L=2e-08 W=8.1e-08 nfin=3
M49 N_M14_g N_M12_d VDD VDD pmos_rvt L=2e-08 W=8.1e-08 nfin=3
M50 N_M14_g N_M14_g VDD VDD pmos_rvt L=2e-08 W=8.1e-08 nfin=3
M51 N_M14_g N_M14_g VDD VDD pmos_rvt L=2e-08 W=8.1e-08 nfin=3
M52 Y A VDD VDD pmos_rvt L=2e-08 W=8.1e-08 nfin=3
M53 Y A VDD VDD pmos_rvt L=2e-08 W=8.1e-08 nfin=3
M54 Y A VDD VDD pmos_rvt L=2e-08 W=8.1e-08 nfin=3
M55 Y A VDD VDD pmos_rvt L=2e-08 W=8.1e-08 nfin=3
M64 N_M28_g N_M28_g VDD VDD pmos_rvt L=2e-08 W=8.1e-08 nfin=3
M65 N_M28_g N_M28_g VDD VDD pmos_rvt L=2e-08 W=8.1e-08 nfin=3
M66 N_M28_g N_M28_d VDD VDD pmos_rvt L=2e-08 W=8.1e-08 nfin=3
M67 N_M28_g N_M28_d VDD VDD pmos_rvt L=2e-08 W=8.1e-08 nfin=3
M60 Y A VDD VDD pmos_rvt L=2e-08 W=8.1e-08 nfin=3
M61 Y A VDD VDD pmos_rvt L=2e-08 W=8.1e-08 nfin=3
M62 Y A VDD VDD pmos_rvt L=2e-08 W=8.1e-08 nfin=3
M63 Y A VDD VDD pmos_rvt L=2e-08 W=8.1e-08 nfin=3
M56 N_M20_g N_M20_g VDD VDD pmos_rvt L=2e-08 W=8.1e-08 nfin=3
M57 N_M20_g N_M20_g VDD VDD pmos_rvt L=2e-08 W=8.1e-08 nfin=3
M58 N_M20_g N_M20_d VDD VDD pmos_rvt L=2e-08 W=8.1e-08 nfin=3
M59 N_M20_g N_M20_d VDD VDD pmos_rvt L=2e-08 W=8.1e-08 nfin=3
M68 Y A VDD VDD pmos_rvt L=2e-08 W=8.1e-08 nfin=3
M69 Y A VDD VDD pmos_rvt L=2e-08 W=8.1e-08 nfin=3
M70 Y A VDD VDD pmos_rvt L=2e-08 W=8.1e-08 nfin=3
M71 Y A VDD VDD pmos_rvt L=2e-08 W=8.1e-08 nfin=3
.ENDS

.SUBCKT CKINVDCx5p33_ASAP7_75t_R A VDD VSS Y
M0 Y A VSS VSS nmos_rvt L=2e-08 W=5.4e-08 nfin=2
M1 Y A VSS VSS nmos_rvt L=2e-08 W=5.4e-08 nfin=2
M16 N_M16_d N_M16_d VSS VSS nmos_rvt L=2e-08 W=8.1e-08 nfin=3
M17 N_M16_d N_M16_d VSS VSS nmos_rvt L=2e-08 W=8.1e-08 nfin=3
M14 N_M16_d N_M14_g VSS VSS nmos_rvt L=2e-08 W=8.1e-08 nfin=3
M15 N_M16_d N_M14_g VSS VSS nmos_rvt L=2e-08 W=8.1e-08 nfin=3
M6 Y A VSS VSS nmos_rvt L=2e-08 W=5.4e-08 nfin=2
M7 Y A VSS VSS nmos_rvt L=2e-08 W=5.4e-08 nfin=2
M8 N_M8_d N_M8_d VSS VSS nmos_rvt L=2e-08 W=8.1e-08 nfin=3
M9 N_M8_d N_M8_d VSS VSS nmos_rvt L=2e-08 W=8.1e-08 nfin=3
M10 N_M8_d N_M10_g VSS VSS nmos_rvt L=2e-08 W=8.1e-08 nfin=3
M11 N_M8_d N_M10_g VSS VSS nmos_rvt L=2e-08 W=8.1e-08 nfin=3
M12 Y A VSS VSS nmos_rvt L=2e-08 W=5.4e-08 nfin=2
M13 Y A VSS VSS nmos_rvt L=2e-08 W=5.4e-08 nfin=2
M4 N_M4_d N_M4_g VSS VSS nmos_rvt L=2e-08 W=8.1e-08 nfin=3
M5 N_M4_d N_M4_g VSS VSS nmos_rvt L=2e-08 W=8.1e-08 nfin=3
M2 N_M4_d N_M4_d VSS VSS nmos_rvt L=2e-08 W=8.1e-08 nfin=3
M3 N_M4_d N_M4_d VSS VSS nmos_rvt L=2e-08 W=8.1e-08 nfin=3
M18 Y A VSS VSS nmos_rvt L=2e-08 W=5.4e-08 nfin=2
M19 Y A VSS VSS nmos_rvt L=2e-08 W=5.4e-08 nfin=2
M20 Y A VDD VDD pmos_rvt L=2e-08 W=5.4e-08 nfin=2
M21 Y A VDD VDD pmos_rvt L=2e-08 W=5.4e-08 nfin=2
M36 N_M14_g N_M16_d VDD VDD pmos_rvt L=2e-08 W=8.1e-08 nfin=3
M37 N_M14_g N_M16_d VDD VDD pmos_rvt L=2e-08 W=8.1e-08 nfin=3
M34 N_M14_g N_M14_g VDD VDD pmos_rvt L=2e-08 W=8.1e-08 nfin=3
M35 N_M14_g N_M14_g VDD VDD pmos_rvt L=2e-08 W=8.1e-08 nfin=3
M26 Y A VDD VDD pmos_rvt L=2e-08 W=5.4e-08 nfin=2
M27 Y A VDD VDD pmos_rvt L=2e-08 W=5.4e-08 nfin=2
M28 N_M10_g N_M8_d VDD VDD pmos_rvt L=2e-08 W=8.1e-08 nfin=3
M29 N_M10_g N_M8_d VDD VDD pmos_rvt L=2e-08 W=8.1e-08 nfin=3
M30 N_M10_g N_M10_g VDD VDD pmos_rvt L=2e-08 W=8.1e-08 nfin=3
M31 N_M10_g N_M10_g VDD VDD pmos_rvt L=2e-08 W=8.1e-08 nfin=3
M32 Y A VDD VDD pmos_rvt L=2e-08 W=5.4e-08 nfin=2
M33 Y A VDD VDD pmos_rvt L=2e-08 W=5.4e-08 nfin=2
M24 N_M4_g N_M4_g VDD VDD pmos_rvt L=2e-08 W=8.1e-08 nfin=3
M25 N_M4_g N_M4_g VDD VDD pmos_rvt L=2e-08 W=8.1e-08 nfin=3
M22 N_M4_g N_M4_d VDD VDD pmos_rvt L=2e-08 W=8.1e-08 nfin=3
M23 N_M4_g N_M4_d VDD VDD pmos_rvt L=2e-08 W=8.1e-08 nfin=3
M38 Y A VDD VDD pmos_rvt L=2e-08 W=5.4e-08 nfin=2
M39 Y A VDD VDD pmos_rvt L=2e-08 W=5.4e-08 nfin=2
.ENDS

.SUBCKT CKINVDCx6p67_ASAP7_75t_R A VDD VSS Y
M0 Y A VSS VSS nmos_rvt L=2e-08 W=5.4e-08 nfin=2
M1 Y A VSS VSS nmos_rvt L=2e-08 W=5.4e-08 nfin=2
M16 N_M16_d N_M16_d VSS VSS nmos_rvt L=2e-08 W=8.1e-08 nfin=3
M17 N_M16_d N_M16_d VSS VSS nmos_rvt L=2e-08 W=8.1e-08 nfin=3
M14 N_M16_d N_M14_g VSS VSS nmos_rvt L=2e-08 W=8.1e-08 nfin=3
M15 N_M16_d N_M14_g VSS VSS nmos_rvt L=2e-08 W=8.1e-08 nfin=3
M6 Y A VSS VSS nmos_rvt L=2e-08 W=5.4e-08 nfin=2
M7 Y A VSS VSS nmos_rvt L=2e-08 W=5.4e-08 nfin=2
M8 N_M8_d N_M8_d VSS VSS nmos_rvt L=2e-08 W=8.1e-08 nfin=3
M9 N_M8_d N_M8_d VSS VSS nmos_rvt L=2e-08 W=8.1e-08 nfin=3
M10 N_M8_d N_M10_g VSS VSS nmos_rvt L=2e-08 W=8.1e-08 nfin=3
M11 N_M8_d N_M10_g VSS VSS nmos_rvt L=2e-08 W=8.1e-08 nfin=3
M12 Y A VSS VSS nmos_rvt L=2e-08 W=5.4e-08 nfin=2
M13 Y A VSS VSS nmos_rvt L=2e-08 W=5.4e-08 nfin=2
M4 N_M4_d N_M4_g VSS VSS nmos_rvt L=2e-08 W=8.1e-08 nfin=3
M5 N_M4_d N_M4_g VSS VSS nmos_rvt L=2e-08 W=8.1e-08 nfin=3
M2 N_M4_d N_M4_d VSS VSS nmos_rvt L=2e-08 W=8.1e-08 nfin=3
M3 N_M4_d N_M4_d VSS VSS nmos_rvt L=2e-08 W=8.1e-08 nfin=3
M18 Y A VSS VSS nmos_rvt L=2e-08 W=5.4e-08 nfin=2
M19 Y A VSS VSS nmos_rvt L=2e-08 W=5.4e-08 nfin=2
M20 Y A VSS VSS nmos_rvt L=2e-08 W=5.4e-08 nfin=2
M21 Y A VSS VSS nmos_rvt L=2e-08 W=5.4e-08 nfin=2
M22 Y A VDD VDD pmos_rvt L=2e-08 W=5.4e-08 nfin=2
M23 Y A VDD VDD pmos_rvt L=2e-08 W=5.4e-08 nfin=2
M38 N_M14_g N_M16_d VDD VDD pmos_rvt L=2e-08 W=8.1e-08 nfin=3
M39 N_M14_g N_M16_d VDD VDD pmos_rvt L=2e-08 W=8.1e-08 nfin=3
M36 N_M14_g N_M14_g VDD VDD pmos_rvt L=2e-08 W=8.1e-08 nfin=3
M37 N_M14_g N_M14_g VDD VDD pmos_rvt L=2e-08 W=8.1e-08 nfin=3
M28 Y A VDD VDD pmos_rvt L=2e-08 W=5.4e-08 nfin=2
M29 Y A VDD VDD pmos_rvt L=2e-08 W=5.4e-08 nfin=2
M30 N_M10_g N_M8_d VDD VDD pmos_rvt L=2e-08 W=8.1e-08 nfin=3
M31 N_M10_g N_M8_d VDD VDD pmos_rvt L=2e-08 W=8.1e-08 nfin=3
M32 N_M10_g N_M10_g VDD VDD pmos_rvt L=2e-08 W=8.1e-08 nfin=3
M33 N_M10_g N_M10_g VDD VDD pmos_rvt L=2e-08 W=8.1e-08 nfin=3
M34 Y A VDD VDD pmos_rvt L=2e-08 W=5.4e-08 nfin=2
M35 Y A VDD VDD pmos_rvt L=2e-08 W=5.4e-08 nfin=2
M26 N_M4_g N_M4_g VDD VDD pmos_rvt L=2e-08 W=8.1e-08 nfin=3
M27 N_M4_g N_M4_g VDD VDD pmos_rvt L=2e-08 W=8.1e-08 nfin=3
M24 N_M4_g N_M4_d VDD VDD pmos_rvt L=2e-08 W=8.1e-08 nfin=3
M25 N_M4_g N_M4_d VDD VDD pmos_rvt L=2e-08 W=8.1e-08 nfin=3
M40 Y A VDD VDD pmos_rvt L=2e-08 W=5.4e-08 nfin=2
M41 Y A VDD VDD pmos_rvt L=2e-08 W=5.4e-08 nfin=2
M42 Y A VDD VDD pmos_rvt L=2e-08 W=5.4e-08 nfin=2
M43 Y A VDD VDD pmos_rvt L=2e-08 W=5.4e-08 nfin=2
.ENDS

.SUBCKT CKINVDCx8_ASAP7_75t_R A VDD VSS Y
M0 Y A VSS VSS nmos_rvt L=2e-08 W=8.1e-08 nfin=3
M1 Y A VSS VSS nmos_rvt L=2e-08 W=8.1e-08 nfin=3
M16 N_M16_d N_M16_d VSS VSS nmos_rvt L=2e-08 W=8.1e-08 nfin=3
M17 N_M16_d N_M16_d VSS VSS nmos_rvt L=2e-08 W=8.1e-08 nfin=3
M14 N_M16_d N_M14_g VSS VSS nmos_rvt L=2e-08 W=8.1e-08 nfin=3
M15 N_M16_d N_M14_g VSS VSS nmos_rvt L=2e-08 W=8.1e-08 nfin=3
M6 Y A VSS VSS nmos_rvt L=2e-08 W=8.1e-08 nfin=3
M7 Y A VSS VSS nmos_rvt L=2e-08 W=8.1e-08 nfin=3
M8 N_M8_d N_M8_d VSS VSS nmos_rvt L=2e-08 W=8.1e-08 nfin=3
M9 N_M8_d N_M8_d VSS VSS nmos_rvt L=2e-08 W=8.1e-08 nfin=3
M10 N_M8_d N_M10_g VSS VSS nmos_rvt L=2e-08 W=8.1e-08 nfin=3
M11 N_M8_d N_M10_g VSS VSS nmos_rvt L=2e-08 W=8.1e-08 nfin=3
M12 Y A VSS VSS nmos_rvt L=2e-08 W=8.1e-08 nfin=3
M13 Y A VSS VSS nmos_rvt L=2e-08 W=8.1e-08 nfin=3
M4 N_M4_d N_M4_g VSS VSS nmos_rvt L=2e-08 W=8.1e-08 nfin=3
M5 N_M4_d N_M4_g VSS VSS nmos_rvt L=2e-08 W=8.1e-08 nfin=3
M2 N_M4_d N_M4_d VSS VSS nmos_rvt L=2e-08 W=8.1e-08 nfin=3
M3 N_M4_d N_M4_d VSS VSS nmos_rvt L=2e-08 W=8.1e-08 nfin=3
M18 Y A VSS VSS nmos_rvt L=2e-08 W=8.1e-08 nfin=3
M19 Y A VSS VSS nmos_rvt L=2e-08 W=8.1e-08 nfin=3
M20 Y A VDD VDD pmos_rvt L=2e-08 W=8.1e-08 nfin=3
M21 Y A VDD VDD pmos_rvt L=2e-08 W=8.1e-08 nfin=3
M36 N_M14_g N_M16_d VDD VDD pmos_rvt L=2e-08 W=8.1e-08 nfin=3
M37 N_M14_g N_M16_d VDD VDD pmos_rvt L=2e-08 W=8.1e-08 nfin=3
M34 N_M14_g N_M14_g VDD VDD pmos_rvt L=2e-08 W=8.1e-08 nfin=3
M35 N_M14_g N_M14_g VDD VDD pmos_rvt L=2e-08 W=8.1e-08 nfin=3
M26 Y A VDD VDD pmos_rvt L=2e-08 W=8.1e-08 nfin=3
M27 Y A VDD VDD pmos_rvt L=2e-08 W=8.1e-08 nfin=3
M28 N_M10_g N_M8_d VDD VDD pmos_rvt L=2e-08 W=8.1e-08 nfin=3
M29 N_M10_g N_M8_d VDD VDD pmos_rvt L=2e-08 W=8.1e-08 nfin=3
M30 N_M10_g N_M10_g VDD VDD pmos_rvt L=2e-08 W=8.1e-08 nfin=3
M31 N_M10_g N_M10_g VDD VDD pmos_rvt L=2e-08 W=8.1e-08 nfin=3
M32 Y A VDD VDD pmos_rvt L=2e-08 W=8.1e-08 nfin=3
M33 Y A VDD VDD pmos_rvt L=2e-08 W=8.1e-08 nfin=3
M24 N_M4_g N_M4_g VDD VDD pmos_rvt L=2e-08 W=8.1e-08 nfin=3
M25 N_M4_g N_M4_g VDD VDD pmos_rvt L=2e-08 W=8.1e-08 nfin=3
M22 N_M4_g N_M4_d VDD VDD pmos_rvt L=2e-08 W=8.1e-08 nfin=3
M23 N_M4_g N_M4_d VDD VDD pmos_rvt L=2e-08 W=8.1e-08 nfin=3
M38 Y A VDD VDD pmos_rvt L=2e-08 W=8.1e-08 nfin=3
M39 Y A VDD VDD pmos_rvt L=2e-08 W=8.1e-08 nfin=3
.ENDS

.SUBCKT CKINVDCx9p33_ASAP7_75t_R A VDD VSS Y
M0 Y A VSS VSS nmos_rvt L=2e-08 W=5.4e-08 nfin=2
M1 Y A VSS VSS nmos_rvt L=2e-08 W=5.4e-08 nfin=2
M20 N_M20_d N_M20_d VSS VSS nmos_rvt L=2e-08 W=8.1e-08 nfin=3
M21 N_M20_d N_M20_d VSS VSS nmos_rvt L=2e-08 W=8.1e-08 nfin=3
M18 N_M20_d N_M18_g VSS VSS nmos_rvt L=2e-08 W=8.1e-08 nfin=3
M19 N_M20_d N_M18_g VSS VSS nmos_rvt L=2e-08 W=8.1e-08 nfin=3
M6 Y A VSS VSS nmos_rvt L=2e-08 W=5.4e-08 nfin=2
M7 Y A VSS VSS nmos_rvt L=2e-08 W=5.4e-08 nfin=2
M8 Y A VSS VSS nmos_rvt L=2e-08 W=5.4e-08 nfin=2
M9 Y A VSS VSS nmos_rvt L=2e-08 W=5.4e-08 nfin=2
M10 N_M10_d N_M10_d VSS VSS nmos_rvt L=2e-08 W=8.1e-08 nfin=3
M11 N_M10_d N_M10_d VSS VSS nmos_rvt L=2e-08 W=8.1e-08 nfin=3
M12 N_M10_d N_M12_g VSS VSS nmos_rvt L=2e-08 W=8.1e-08 nfin=3
M13 N_M10_d N_M12_g VSS VSS nmos_rvt L=2e-08 W=8.1e-08 nfin=3
M14 Y A VSS VSS nmos_rvt L=2e-08 W=5.4e-08 nfin=2
M15 Y A VSS VSS nmos_rvt L=2e-08 W=5.4e-08 nfin=2
M16 Y A VSS VSS nmos_rvt L=2e-08 W=5.4e-08 nfin=2
M17 Y A VSS VSS nmos_rvt L=2e-08 W=5.4e-08 nfin=2
M4 N_M4_d N_M4_g VSS VSS nmos_rvt L=2e-08 W=8.1e-08 nfin=3
M5 N_M4_d N_M4_g VSS VSS nmos_rvt L=2e-08 W=8.1e-08 nfin=3
M2 N_M4_d N_M4_d VSS VSS nmos_rvt L=2e-08 W=8.1e-08 nfin=3
M3 N_M4_d N_M4_d VSS VSS nmos_rvt L=2e-08 W=8.1e-08 nfin=3
M22 Y A VSS VSS nmos_rvt L=2e-08 W=5.4e-08 nfin=2
M23 Y A VSS VSS nmos_rvt L=2e-08 W=5.4e-08 nfin=2
M24 Y A VSS VSS nmos_rvt L=2e-08 W=5.4e-08 nfin=2
M25 Y A VSS VSS nmos_rvt L=2e-08 W=5.4e-08 nfin=2
M26 Y A VDD VDD pmos_rvt L=2e-08 W=5.4e-08 nfin=2
M27 Y A VDD VDD pmos_rvt L=2e-08 W=5.4e-08 nfin=2
M46 N_M18_g N_M20_d VDD VDD pmos_rvt L=2e-08 W=8.1e-08 nfin=3
M47 N_M18_g N_M20_d VDD VDD pmos_rvt L=2e-08 W=8.1e-08 nfin=3
M44 N_M18_g N_M18_g VDD VDD pmos_rvt L=2e-08 W=8.1e-08 nfin=3
M45 N_M18_g N_M18_g VDD VDD pmos_rvt L=2e-08 W=8.1e-08 nfin=3
M32 Y A VDD VDD pmos_rvt L=2e-08 W=5.4e-08 nfin=2
M33 Y A VDD VDD pmos_rvt L=2e-08 W=5.4e-08 nfin=2
M34 Y A VDD VDD pmos_rvt L=2e-08 W=5.4e-08 nfin=2
M35 Y A VDD VDD pmos_rvt L=2e-08 W=5.4e-08 nfin=2
M36 N_M12_g N_M10_d VDD VDD pmos_rvt L=2e-08 W=8.1e-08 nfin=3
M37 N_M12_g N_M10_d VDD VDD pmos_rvt L=2e-08 W=8.1e-08 nfin=3
M38 N_M12_g N_M12_g VDD VDD pmos_rvt L=2e-08 W=8.1e-08 nfin=3
M39 N_M12_g N_M12_g VDD VDD pmos_rvt L=2e-08 W=8.1e-08 nfin=3
M40 Y A VDD VDD pmos_rvt L=2e-08 W=5.4e-08 nfin=2
M41 Y A VDD VDD pmos_rvt L=2e-08 W=5.4e-08 nfin=2
M42 Y A VDD VDD pmos_rvt L=2e-08 W=5.4e-08 nfin=2
M43 Y A VDD VDD pmos_rvt L=2e-08 W=5.4e-08 nfin=2
M30 N_M4_g N_M4_g VDD VDD pmos_rvt L=2e-08 W=8.1e-08 nfin=3
M31 N_M4_g N_M4_g VDD VDD pmos_rvt L=2e-08 W=8.1e-08 nfin=3
M28 N_M4_g N_M4_d VDD VDD pmos_rvt L=2e-08 W=8.1e-08 nfin=3
M29 N_M4_g N_M4_d VDD VDD pmos_rvt L=2e-08 W=8.1e-08 nfin=3
M48 Y A VDD VDD pmos_rvt L=2e-08 W=5.4e-08 nfin=2
M49 Y A VDD VDD pmos_rvt L=2e-08 W=5.4e-08 nfin=2
M50 Y A VDD VDD pmos_rvt L=2e-08 W=5.4e-08 nfin=2
M51 Y A VDD VDD pmos_rvt L=2e-08 W=5.4e-08 nfin=2
.ENDS

.SUBCKT DECAPx10_ASAP7_75t_R VDD VSS
M0 VSS N_M0_g N_M0_s VSS nmos_rvt L=2e-08 W=8.1e-08 nfin=3
M1 VSS N_M0_g N_M0_s VSS nmos_rvt L=2e-08 W=8.1e-08 nfin=3
M2 VSS N_M0_g N_M0_s VSS nmos_rvt L=2e-08 W=8.1e-08 nfin=3
M3 VSS N_M0_g N_M0_s VSS nmos_rvt L=2e-08 W=8.1e-08 nfin=3
M4 VSS N_M0_g N_M0_s VSS nmos_rvt L=2e-08 W=8.1e-08 nfin=3
M5 VSS N_M0_g N_M0_s VSS nmos_rvt L=2e-08 W=8.1e-08 nfin=3
M6 VSS N_M0_g N_M0_s VSS nmos_rvt L=2e-08 W=8.1e-08 nfin=3
M7 VSS N_M0_g N_M0_s VSS nmos_rvt L=2e-08 W=8.1e-08 nfin=3
M8 VSS N_M0_g N_M0_s VSS nmos_rvt L=2e-08 W=8.1e-08 nfin=3
M9 VSS N_M0_g N_M0_s VSS nmos_rvt L=2e-08 W=8.1e-08 nfin=3
M10 VDD N_M0_s N_M0_g VDD pmos_rvt L=2e-08 W=8.1e-08 nfin=3
M11 VDD N_M0_s N_M0_g VDD pmos_rvt L=2e-08 W=8.1e-08 nfin=3
M12 VDD N_M0_s N_M0_g VDD pmos_rvt L=2e-08 W=8.1e-08 nfin=3
M13 VDD N_M0_s N_M0_g VDD pmos_rvt L=2e-08 W=8.1e-08 nfin=3
M14 VDD N_M0_s N_M0_g VDD pmos_rvt L=2e-08 W=8.1e-08 nfin=3
M15 VDD N_M0_s N_M0_g VDD pmos_rvt L=2e-08 W=8.1e-08 nfin=3
M16 VDD N_M0_s N_M0_g VDD pmos_rvt L=2e-08 W=8.1e-08 nfin=3
M17 VDD N_M0_s N_M0_g VDD pmos_rvt L=2e-08 W=8.1e-08 nfin=3
M18 VDD N_M0_s N_M0_g VDD pmos_rvt L=2e-08 W=8.1e-08 nfin=3
M19 VDD N_M0_s N_M0_g VDD pmos_rvt L=2e-08 W=8.1e-08 nfin=3
.ENDS

.SUBCKT DECAPx1_ASAP7_75t_R VDD VSS
M0 VSS N_M0_g N_M0_s VSS nmos_rvt L=2e-08 W=8.1e-08 nfin=3
M1 N_M0_g N_M0_s VDD VDD pmos_rvt L=2e-08 W=8.1e-08 nfin=3
.ENDS

.SUBCKT DECAPx2_ASAP7_75t_R VDD VSS
M0 VSS N_M0_g N_M0_s VSS nmos_rvt L=2e-08 W=8.1e-08 nfin=3
M1 VSS N_M0_g N_M0_s VSS nmos_rvt L=2e-08 W=8.1e-08 nfin=3
M2 VDD N_M0_s N_M0_g VDD pmos_rvt L=2e-08 W=8.1e-08 nfin=3
M3 VDD N_M0_s N_M0_g VDD pmos_rvt L=2e-08 W=8.1e-08 nfin=3
.ENDS

.SUBCKT DECAPx2b_ASAP7_75t_R VDD VSS
M0 N_M0_d N_M0_d VSS VSS nmos_rvt L=2e-08 W=8.1e-08 nfin=3
M1 N_M0_d N_M0_d VSS VSS nmos_rvt L=2e-08 W=8.1e-08 nfin=3
M2 N_M0_d N_M2_g VSS VSS nmos_rvt L=2e-08 W=8.1e-08 nfin=3
M3 N_M0_d N_M2_g VSS VSS nmos_rvt L=2e-08 W=8.1e-08 nfin=3
M4 N_M2_g N_M0_d VDD VDD pmos_rvt L=2e-08 W=8.1e-08 nfin=3
M5 N_M2_g N_M0_d VDD VDD pmos_rvt L=2e-08 W=8.1e-08 nfin=3
M6 N_M2_g N_M2_g VDD VDD pmos_rvt L=2e-08 W=8.1e-08 nfin=3
M7 N_M2_g N_M2_g VDD VDD pmos_rvt L=2e-08 W=8.1e-08 nfin=3
.ENDS

.SUBCKT DECAPx4_ASAP7_75t_R VDD VSS
M0 VSS N_M0_g N_M0_s VSS nmos_rvt L=2e-08 W=8.1e-08 nfin=3
M1 VSS N_M0_g N_M0_s VSS nmos_rvt L=2e-08 W=8.1e-08 nfin=3
M2 VSS N_M0_g N_M0_s VSS nmos_rvt L=2e-08 W=8.1e-08 nfin=3
M3 VSS N_M0_g N_M0_s VSS nmos_rvt L=2e-08 W=8.1e-08 nfin=3
M4 VDD N_M0_s N_M0_g VDD pmos_rvt L=2e-08 W=8.1e-08 nfin=3
M5 VDD N_M0_s N_M0_g VDD pmos_rvt L=2e-08 W=8.1e-08 nfin=3
M6 VDD N_M0_s N_M0_g VDD pmos_rvt L=2e-08 W=8.1e-08 nfin=3
M7 VDD N_M0_s N_M0_g VDD pmos_rvt L=2e-08 W=8.1e-08 nfin=3
.ENDS

.SUBCKT DECAPx6_ASAP7_75t_R VDD VSS
M0 VSS N_M0_g N_M0_s VSS nmos_rvt L=2e-08 W=8.1e-08 nfin=3
M1 VSS N_M0_g N_M0_s VSS nmos_rvt L=2e-08 W=8.1e-08 nfin=3
M2 VSS N_M0_g N_M0_s VSS nmos_rvt L=2e-08 W=8.1e-08 nfin=3
M3 VSS N_M0_g N_M0_s VSS nmos_rvt L=2e-08 W=8.1e-08 nfin=3
M4 VSS N_M0_g N_M0_s VSS nmos_rvt L=2e-08 W=8.1e-08 nfin=3
M5 VSS N_M0_g N_M0_s VSS nmos_rvt L=2e-08 W=8.1e-08 nfin=3
M6 VDD N_M0_s N_M0_g VDD pmos_rvt L=2e-08 W=8.1e-08 nfin=3
M7 VDD N_M0_s N_M0_g VDD pmos_rvt L=2e-08 W=8.1e-08 nfin=3
M8 VDD N_M0_s N_M0_g VDD pmos_rvt L=2e-08 W=8.1e-08 nfin=3
M9 VDD N_M0_s N_M0_g VDD pmos_rvt L=2e-08 W=8.1e-08 nfin=3
M10 VDD N_M0_s N_M0_g VDD pmos_rvt L=2e-08 W=8.1e-08 nfin=3
M11 VDD N_M0_s N_M0_g VDD pmos_rvt L=2e-08 W=8.1e-08 nfin=3
.ENDS

.SUBCKT DFFASRHQNx1_ASAP7_75t_R CLK D QN RESETn SETn VDD VSS
M0 VSS CLK N_M0_s VSS nmos_rvt L=2e-08 W=5.4e-08 nfin=2
M1 N_M1_d N_M0_s VSS VSS nmos_rvt L=2e-08 W=5.4e-08 nfin=2
M2 N_M2_d D VSS VSS nmos_rvt L=2e-08 W=8.1e-08 nfin=3
M3 N_M3_d N_M0_s N_M2_d VSS nmos_rvt L=2e-08 W=8.1e-08 nfin=3
M4 N_M4_d N_M1_d N_M3_d VSS nmos_rvt L=2e-08 W=2.7e-08 nfin=1
M5 N_M5_d N_M5_g N_M4_d VSS nmos_rvt L=2e-08 W=2.7e-08 nfin=1
M6 VSS RESETn N_M5_d VSS nmos_rvt L=2e-08 W=2.7e-08 nfin=1
M7 N_M7_d SETn VSS VSS nmos_rvt L=2e-08 W=5.4e-08 nfin=2
M8 N_M5_g N_M3_d N_M7_d VSS nmos_rvt L=2e-08 W=5.4e-08 nfin=2
M9 N_M9_d N_M1_d N_M5_g VSS nmos_rvt L=2e-08 W=2.7e-08 nfin=1
M10 N_M10_d N_M0_s N_M9_d VSS nmos_rvt L=2e-08 W=5.4e-08 nfin=2
M11 N_M11_d N_M11_g N_M10_d VSS nmos_rvt L=2e-08 W=5.4e-08 nfin=2
M12 VSS SETn N_M11_d VSS nmos_rvt L=2e-08 W=5.4e-08 nfin=2
M13 N_M13_d RESETn VSS VSS nmos_rvt L=2e-08 W=5.4e-08 nfin=2
M14 N_M11_g N_M9_d N_M13_d VSS nmos_rvt L=2e-08 W=5.4e-08 nfin=2
M15 QN N_M9_d VSS VSS nmos_rvt L=2e-08 W=8.1e-08 nfin=3
M16 VDD CLK N_M0_s VDD pmos_rvt L=2e-08 W=5.4e-08 nfin=2
M17 N_M1_d N_M0_s VDD VDD pmos_rvt L=2e-08 W=5.4e-08 nfin=2
M18 N_M18_d D VDD VDD pmos_rvt L=2e-08 W=8.1e-08 nfin=3
M19 N_M3_d N_M1_d N_M18_d VDD pmos_rvt L=2e-08 W=8.1e-08 nfin=3
M20 N_M20_d N_M0_s N_M3_d VDD pmos_rvt L=2e-08 W=5.4e-08 nfin=2
M21 N_M20_d N_M5_g VDD VDD pmos_rvt L=2e-08 W=5.4e-08 nfin=2
M22 VDD RESETn N_M20_d VDD pmos_rvt L=2e-08 W=5.4e-08 nfin=2
M23 N_M5_g SETn VDD VDD pmos_rvt L=2e-08 W=2.7e-08 nfin=1
M24 VDD N_M3_d N_M5_g VDD pmos_rvt L=2e-08 W=2.7e-08 nfin=1
M25 N_M25_d SETn VDD VDD pmos_rvt L=2e-08 W=5.4e-08 nfin=2
M26 N_M9_d N_M1_d N_M25_d VDD pmos_rvt L=2e-08 W=5.4e-08 nfin=2
M27 N_M5_g N_M0_s N_M9_d VDD pmos_rvt L=2e-08 W=2.7e-08 nfin=1
M28 N_M5_g SETn VDD VDD pmos_rvt L=2e-08 W=2.7e-08 nfin=1
M29 N_M11_g RESETn VDD VDD pmos_rvt L=2e-08 W=2.7e-08 nfin=1
M30 VDD N_M9_d N_M11_g VDD pmos_rvt L=2e-08 W=2.7e-08 nfin=1
M31 N_M25_d N_M11_g VDD VDD pmos_rvt L=2e-08 W=2.7e-08 nfin=1
M32 QN N_M9_d VDD VDD pmos_rvt L=2e-08 W=8.1e-08 nfin=3
.ENDS

.SUBCKT DFFHQNx1_ASAP7_75t_R CLK D QN VDD VSS
M0 VSS CLK N_M0_s VSS nmos_rvt L=2e-08 W=5.4e-08 nfin=2
M1 N_M1_d N_M0_s VSS VSS nmos_rvt L=2e-08 W=5.4e-08 nfin=2
M2 N_M2_d D VSS VSS nmos_rvt L=2e-08 W=8.1e-08 nfin=3
M3 N_M3_d N_M0_s N_M2_d VSS nmos_rvt L=2e-08 W=8.1e-08 nfin=3
M4 N_M4_d N_M1_d N_M3_d VSS nmos_rvt L=2e-08 W=2.7e-08 nfin=1
M5 VSS N_M5_g N_M4_d VSS nmos_rvt L=2e-08 W=2.7e-08 nfin=1
M6 N_M5_g N_M3_d VSS VSS nmos_rvt L=2e-08 W=2.7e-08 nfin=1
M7 N_M7_d N_M1_d N_M5_g VSS nmos_rvt L=2e-08 W=2.7e-08 nfin=1
M8 N_M8_d N_M0_s N_M7_d VSS nmos_rvt L=2e-08 W=2.7e-08 nfin=1
M9 VSS N_M9_g N_M8_d VSS nmos_rvt L=2e-08 W=2.7e-08 nfin=1
M10 N_M9_g N_M7_d VSS VSS nmos_rvt L=2e-08 W=2.7e-08 nfin=1
M11 QN N_M7_d VSS VSS nmos_rvt L=2e-08 W=8.1e-08 nfin=3
M12 VDD CLK N_M0_s VDD pmos_rvt L=2e-08 W=5.4e-08 nfin=2
M13 N_M1_d N_M0_s VDD VDD pmos_rvt L=2e-08 W=5.4e-08 nfin=2
M14 N_M14_d D VDD VDD pmos_rvt L=2e-08 W=8.1e-08 nfin=3
M15 N_M3_d N_M1_d N_M14_d VDD pmos_rvt L=2e-08 W=8.1e-08 nfin=3
M16 N_M16_d N_M0_s N_M3_d VDD pmos_rvt L=2e-08 W=2.7e-08 nfin=1
M17 VDD N_M5_g N_M16_d VDD pmos_rvt L=2e-08 W=2.7e-08 nfin=1
M18 N_M5_g N_M3_d VDD VDD pmos_rvt L=2e-08 W=2.7e-08 nfin=1
M19 N_M7_d N_M0_s N_M5_g VDD pmos_rvt L=2e-08 W=2.7e-08 nfin=1
M20 N_M20_d N_M1_d N_M7_d VDD pmos_rvt L=2e-08 W=2.7e-08 nfin=1
M21 VDD N_M9_g N_M20_d VDD pmos_rvt L=2e-08 W=2.7e-08 nfin=1
M22 N_M9_g N_M7_d VDD VDD pmos_rvt L=2e-08 W=2.7e-08 nfin=1
M23 QN N_M7_d VDD VDD pmos_rvt L=2e-08 W=8.1e-08 nfin=3
.ENDS

.SUBCKT DFFHQNx2_ASAP7_75t_R CLK D QN VDD VSS
M0 VSS CLK N_M0_s VSS nmos_rvt L=2e-08 W=5.4e-08 nfin=2
M1 N_M1_d N_M0_s VSS VSS nmos_rvt L=2e-08 W=5.4e-08 nfin=2
M2 N_M2_d D VSS VSS nmos_rvt L=2e-08 W=8.1e-08 nfin=3
M3 N_M3_d N_M0_s N_M2_d VSS nmos_rvt L=2e-08 W=8.1e-08 nfin=3
M4 N_M4_d N_M1_d N_M3_d VSS nmos_rvt L=2e-08 W=2.7e-08 nfin=1
M5 VSS N_M5_g N_M4_d VSS nmos_rvt L=2e-08 W=2.7e-08 nfin=1
M6 N_M5_g N_M3_d VSS VSS nmos_rvt L=2e-08 W=2.7e-08 nfin=1
M7 N_M7_d N_M1_d N_M5_g VSS nmos_rvt L=2e-08 W=2.7e-08 nfin=1
M8 N_M8_d N_M0_s N_M7_d VSS nmos_rvt L=2e-08 W=2.7e-08 nfin=1
M9 VSS N_M9_g N_M8_d VSS nmos_rvt L=2e-08 W=2.7e-08 nfin=1
M10 N_M9_g N_M7_d VSS VSS nmos_rvt L=2e-08 W=2.7e-08 nfin=1
M11 QN N_M7_d VSS VSS nmos_rvt L=2e-08 W=8.1e-08 nfin=3
M12 QN N_M7_d VSS VSS nmos_rvt L=2e-08 W=8.1e-08 nfin=3
M13 VDD CLK N_M0_s VDD pmos_rvt L=2e-08 W=5.4e-08 nfin=2
M14 N_M1_d N_M0_s VDD VDD pmos_rvt L=2e-08 W=5.4e-08 nfin=2
M15 N_M15_d D VDD VDD pmos_rvt L=2e-08 W=8.1e-08 nfin=3
M16 N_M3_d N_M1_d N_M15_d VDD pmos_rvt L=2e-08 W=8.1e-08 nfin=3
M17 N_M17_d N_M0_s N_M3_d VDD pmos_rvt L=2e-08 W=2.7e-08 nfin=1
M18 VDD N_M5_g N_M17_d VDD pmos_rvt L=2e-08 W=2.7e-08 nfin=1
M19 N_M5_g N_M3_d VDD VDD pmos_rvt L=2e-08 W=2.7e-08 nfin=1
M20 N_M7_d N_M0_s N_M5_g VDD pmos_rvt L=2e-08 W=2.7e-08 nfin=1
M21 N_M21_d N_M1_d N_M7_d VDD pmos_rvt L=2e-08 W=2.7e-08 nfin=1
M22 VDD N_M9_g N_M21_d VDD pmos_rvt L=2e-08 W=2.7e-08 nfin=1
M23 N_M9_g N_M7_d VDD VDD pmos_rvt L=2e-08 W=2.7e-08 nfin=1
M24 QN N_M7_d VDD VDD pmos_rvt L=2e-08 W=8.1e-08 nfin=3
M25 QN N_M7_d VDD VDD pmos_rvt L=2e-08 W=8.1e-08 nfin=3
.ENDS

.SUBCKT DFFHQNx3_ASAP7_75t_R CLK D QN VDD VSS
M0 VSS CLK N_M0_s VSS nmos_rvt L=2e-08 W=5.4e-08 nfin=2
M1 N_M1_d N_M0_s VSS VSS nmos_rvt L=2e-08 W=5.4e-08 nfin=2
M2 N_M2_d D VSS VSS nmos_rvt L=2e-08 W=8.1e-08 nfin=3
M3 N_M3_d N_M0_s N_M2_d VSS nmos_rvt L=2e-08 W=8.1e-08 nfin=3
M4 N_M4_d N_M1_d N_M3_d VSS nmos_rvt L=2e-08 W=2.7e-08 nfin=1
M5 VSS N_M5_g N_M4_d VSS nmos_rvt L=2e-08 W=2.7e-08 nfin=1
M6 N_M5_g N_M3_d VSS VSS nmos_rvt L=2e-08 W=2.7e-08 nfin=1
M7 N_M7_d N_M1_d N_M5_g VSS nmos_rvt L=2e-08 W=2.7e-08 nfin=1
M8 N_M8_d N_M0_s N_M7_d VSS nmos_rvt L=2e-08 W=2.7e-08 nfin=1
M9 VSS N_M9_g N_M8_d VSS nmos_rvt L=2e-08 W=2.7e-08 nfin=1
M10 N_M9_g N_M7_d VSS VSS nmos_rvt L=2e-08 W=2.7e-08 nfin=1
M11 QN N_M7_d VSS VSS nmos_rvt L=2e-08 W=8.1e-08 nfin=3
M12 QN N_M7_d VSS VSS nmos_rvt L=2e-08 W=8.1e-08 nfin=3
M13 QN N_M7_d VSS VSS nmos_rvt L=2e-08 W=8.1e-08 nfin=3
M14 VDD CLK N_M0_s VDD pmos_rvt L=2e-08 W=5.4e-08 nfin=2
M15 N_M1_d N_M0_s VDD VDD pmos_rvt L=2e-08 W=5.4e-08 nfin=2
M16 N_M16_d D VDD VDD pmos_rvt L=2e-08 W=8.1e-08 nfin=3
M17 N_M3_d N_M1_d N_M16_d VDD pmos_rvt L=2e-08 W=8.1e-08 nfin=3
M18 N_M18_d N_M0_s N_M3_d VDD pmos_rvt L=2e-08 W=2.7e-08 nfin=1
M19 VDD N_M5_g N_M18_d VDD pmos_rvt L=2e-08 W=2.7e-08 nfin=1
M20 N_M5_g N_M3_d VDD VDD pmos_rvt L=2e-08 W=2.7e-08 nfin=1
M21 N_M7_d N_M0_s N_M5_g VDD pmos_rvt L=2e-08 W=2.7e-08 nfin=1
M22 N_M22_d N_M1_d N_M7_d VDD pmos_rvt L=2e-08 W=2.7e-08 nfin=1
M23 VDD N_M9_g N_M22_d VDD pmos_rvt L=2e-08 W=2.7e-08 nfin=1
M24 N_M9_g N_M7_d VDD VDD pmos_rvt L=2e-08 W=2.7e-08 nfin=1
M25 QN N_M7_d VDD VDD pmos_rvt L=2e-08 W=8.1e-08 nfin=3
M26 QN N_M7_d VDD VDD pmos_rvt L=2e-08 W=8.1e-08 nfin=3
M27 QN N_M7_d VDD VDD pmos_rvt L=2e-08 W=8.1e-08 nfin=3
.ENDS

.SUBCKT DFFHQx4_ASAP7_75t_R CLK D Q VDD VSS
M0 VSS CLK N_M0_s VSS nmos_rvt L=2e-08 W=5.4e-08 nfin=2
M1 N_M1_d N_M0_s VSS VSS nmos_rvt L=2e-08 W=5.4e-08 nfin=2
M2 N_M2_d D VSS VSS nmos_rvt L=2e-08 W=8.1e-08 nfin=3
M3 N_M3_d N_M0_s N_M2_d VSS nmos_rvt L=2e-08 W=8.1e-08 nfin=3
M4 N_M4_d N_M1_d N_M3_d VSS nmos_rvt L=2e-08 W=2.7e-08 nfin=1
M5 VSS N_M5_g N_M4_d VSS nmos_rvt L=2e-08 W=2.7e-08 nfin=1
M6 N_M5_g N_M3_d VSS VSS nmos_rvt L=2e-08 W=2.7e-08 nfin=1
M7 N_M7_d N_M1_d N_M5_g VSS nmos_rvt L=2e-08 W=2.7e-08 nfin=1
M8 N_M8_d N_M0_s N_M7_d VSS nmos_rvt L=2e-08 W=2.7e-08 nfin=1
M9 VSS N_M9_g N_M8_d VSS nmos_rvt L=2e-08 W=2.7e-08 nfin=1
M10 N_M9_g N_M7_d VSS VSS nmos_rvt L=2e-08 W=2.7e-08 nfin=1
M11 N_M11_d N_M7_d VSS VSS nmos_rvt L=2e-08 W=8.1e-08 nfin=3
M12 N_M11_d N_M7_d VSS VSS nmos_rvt L=2e-08 W=8.1e-08 nfin=3
M13 Q N_M11_d VSS VSS nmos_rvt L=2e-08 W=8.1e-08 nfin=3
M14 Q N_M11_d VSS VSS nmos_rvt L=2e-08 W=8.1e-08 nfin=3
M15 Q N_M11_d VSS VSS nmos_rvt L=2e-08 W=8.1e-08 nfin=3
M16 Q N_M11_d VSS VSS nmos_rvt L=2e-08 W=8.1e-08 nfin=3
M17 VDD CLK N_M0_s VDD pmos_rvt L=2e-08 W=5.4e-08 nfin=2
M18 N_M1_d N_M0_s VDD VDD pmos_rvt L=2e-08 W=5.4e-08 nfin=2
M19 N_M19_d D VDD VDD pmos_rvt L=2e-08 W=8.1e-08 nfin=3
M20 N_M3_d N_M1_d N_M19_d VDD pmos_rvt L=2e-08 W=8.1e-08 nfin=3
M21 N_M21_d N_M0_s N_M3_d VDD pmos_rvt L=2e-08 W=2.7e-08 nfin=1
M22 VDD N_M5_g N_M21_d VDD pmos_rvt L=2e-08 W=2.7e-08 nfin=1
M23 N_M5_g N_M3_d VDD VDD pmos_rvt L=2e-08 W=2.7e-08 nfin=1
M24 N_M7_d N_M0_s N_M5_g VDD pmos_rvt L=2e-08 W=2.7e-08 nfin=1
M25 N_M25_d N_M1_d N_M7_d VDD pmos_rvt L=2e-08 W=2.7e-08 nfin=1
M26 VDD N_M9_g N_M25_d VDD pmos_rvt L=2e-08 W=2.7e-08 nfin=1
M27 N_M9_g N_M7_d VDD VDD pmos_rvt L=2e-08 W=2.7e-08 nfin=1
M28 N_M11_d N_M7_d VDD VDD pmos_rvt L=2e-08 W=8.1e-08 nfin=3
M29 N_M11_d N_M7_d VDD VDD pmos_rvt L=2e-08 W=8.1e-08 nfin=3
M30 Q N_M11_d VDD VDD pmos_rvt L=2e-08 W=8.1e-08 nfin=3
M31 Q N_M11_d VDD VDD pmos_rvt L=2e-08 W=8.1e-08 nfin=3
M32 Q N_M11_d VDD VDD pmos_rvt L=2e-08 W=8.1e-08 nfin=3
M33 Q N_M11_d VDD VDD pmos_rvt L=2e-08 W=8.1e-08 nfin=3
.ENDS

.SUBCKT DFFLQNx1_ASAP7_75t_R CLK D QN VDD VSS
M0 VSS CLK N_M0_s VSS nmos_rvt L=2e-08 W=5.4e-08 nfin=2
M1 N_M1_d N_M0_s VSS VSS nmos_rvt L=2e-08 W=5.4e-08 nfin=2
M2 N_M2_d D VSS VSS nmos_rvt L=2e-08 W=8.1e-08 nfin=3
M3 N_M3_d N_M1_d N_M2_d VSS nmos_rvt L=2e-08 W=8.1e-08 nfin=3
M4 N_M4_d N_M0_s N_M3_d VSS nmos_rvt L=2e-08 W=2.7e-08 nfin=1
M5 VSS N_M5_g N_M4_d VSS nmos_rvt L=2e-08 W=2.7e-08 nfin=1
M6 N_M5_g N_M3_d VSS VSS nmos_rvt L=2e-08 W=2.7e-08 nfin=1
M7 N_M7_d N_M0_s N_M5_g VSS nmos_rvt L=2e-08 W=2.7e-08 nfin=1
M8 N_M8_d N_M1_d N_M7_d VSS nmos_rvt L=2e-08 W=2.7e-08 nfin=1
M9 VSS N_M9_g N_M8_d VSS nmos_rvt L=2e-08 W=2.7e-08 nfin=1
M10 N_M9_g N_M7_d VSS VSS nmos_rvt L=2e-08 W=2.7e-08 nfin=1
M11 QN N_M7_d VSS VSS nmos_rvt L=2e-08 W=8.1e-08 nfin=3
M12 VDD CLK N_M0_s VDD pmos_rvt L=2e-08 W=5.4e-08 nfin=2
M13 N_M1_d N_M0_s VDD VDD pmos_rvt L=2e-08 W=5.4e-08 nfin=2
M14 N_M14_d D VDD VDD pmos_rvt L=2e-08 W=8.1e-08 nfin=3
M15 N_M3_d N_M0_s N_M14_d VDD pmos_rvt L=2e-08 W=8.1e-08 nfin=3
M16 N_M16_d N_M1_d N_M3_d VDD pmos_rvt L=2e-08 W=2.7e-08 nfin=1
M17 VDD N_M5_g N_M16_d VDD pmos_rvt L=2e-08 W=2.7e-08 nfin=1
M18 N_M5_g N_M3_d VDD VDD pmos_rvt L=2e-08 W=2.7e-08 nfin=1
M19 N_M7_d N_M1_d N_M5_g VDD pmos_rvt L=2e-08 W=2.7e-08 nfin=1
M20 N_M20_d N_M0_s N_M7_d VDD pmos_rvt L=2e-08 W=2.7e-08 nfin=1
M21 VDD N_M9_g N_M20_d VDD pmos_rvt L=2e-08 W=2.7e-08 nfin=1
M22 N_M9_g N_M7_d VDD VDD pmos_rvt L=2e-08 W=2.7e-08 nfin=1
M23 QN N_M7_d VDD VDD pmos_rvt L=2e-08 W=8.1e-08 nfin=3
.ENDS

.SUBCKT DFFLQNx2_ASAP7_75t_R CLK D QN VDD VSS
M0 VSS CLK N_M0_s VSS nmos_rvt L=2e-08 W=5.4e-08 nfin=2
M1 N_M1_d N_M0_s VSS VSS nmos_rvt L=2e-08 W=5.4e-08 nfin=2
M2 N_M2_d D VSS VSS nmos_rvt L=2e-08 W=8.1e-08 nfin=3
M3 N_M3_d N_M1_d N_M2_d VSS nmos_rvt L=2e-08 W=8.1e-08 nfin=3
M4 N_M4_d N_M0_s N_M3_d VSS nmos_rvt L=2e-08 W=2.7e-08 nfin=1
M5 VSS N_M5_g N_M4_d VSS nmos_rvt L=2e-08 W=2.7e-08 nfin=1
M6 N_M5_g N_M3_d VSS VSS nmos_rvt L=2e-08 W=2.7e-08 nfin=1
M7 N_M7_d N_M0_s N_M5_g VSS nmos_rvt L=2e-08 W=2.7e-08 nfin=1
M8 N_M8_d N_M1_d N_M7_d VSS nmos_rvt L=2e-08 W=2.7e-08 nfin=1
M9 VSS N_M9_g N_M8_d VSS nmos_rvt L=2e-08 W=2.7e-08 nfin=1
M10 N_M9_g N_M7_d VSS VSS nmos_rvt L=2e-08 W=2.7e-08 nfin=1
M11 QN N_M7_d VSS VSS nmos_rvt L=2e-08 W=8.1e-08 nfin=3
M12 QN N_M7_d VSS VSS nmos_rvt L=2e-08 W=8.1e-08 nfin=3
M13 VDD CLK N_M0_s VDD pmos_rvt L=2e-08 W=5.4e-08 nfin=2
M14 N_M1_d N_M0_s VDD VDD pmos_rvt L=2e-08 W=5.4e-08 nfin=2
M15 N_M15_d D VDD VDD pmos_rvt L=2e-08 W=8.1e-08 nfin=3
M16 N_M3_d N_M0_s N_M15_d VDD pmos_rvt L=2e-08 W=8.1e-08 nfin=3
M17 N_M17_d N_M1_d N_M3_d VDD pmos_rvt L=2e-08 W=2.7e-08 nfin=1
M18 VDD N_M5_g N_M17_d VDD pmos_rvt L=2e-08 W=2.7e-08 nfin=1
M19 N_M5_g N_M3_d VDD VDD pmos_rvt L=2e-08 W=2.7e-08 nfin=1
M20 N_M7_d N_M1_d N_M5_g VDD pmos_rvt L=2e-08 W=2.7e-08 nfin=1
M21 N_M21_d N_M0_s N_M7_d VDD pmos_rvt L=2e-08 W=2.7e-08 nfin=1
M22 VDD N_M9_g N_M21_d VDD pmos_rvt L=2e-08 W=2.7e-08 nfin=1
M23 N_M9_g N_M7_d VDD VDD pmos_rvt L=2e-08 W=2.7e-08 nfin=1
M24 QN N_M7_d VDD VDD pmos_rvt L=2e-08 W=8.1e-08 nfin=3
M25 QN N_M7_d VDD VDD pmos_rvt L=2e-08 W=8.1e-08 nfin=3
.ENDS

.SUBCKT DFFLQNx3_ASAP7_75t_R CLK D QN VDD VSS
M0 VSS CLK N_M0_s VSS nmos_rvt L=2e-08 W=5.4e-08 nfin=2
M1 N_M1_d N_M0_s VSS VSS nmos_rvt L=2e-08 W=5.4e-08 nfin=2
M2 N_M2_d D VSS VSS nmos_rvt L=2e-08 W=8.1e-08 nfin=3
M3 N_M3_d N_M1_d N_M2_d VSS nmos_rvt L=2e-08 W=8.1e-08 nfin=3
M4 N_M4_d N_M0_s N_M3_d VSS nmos_rvt L=2e-08 W=2.7e-08 nfin=1
M5 VSS N_M5_g N_M4_d VSS nmos_rvt L=2e-08 W=2.7e-08 nfin=1
M6 N_M5_g N_M3_d VSS VSS nmos_rvt L=2e-08 W=2.7e-08 nfin=1
M7 N_M7_d N_M0_s N_M5_g VSS nmos_rvt L=2e-08 W=2.7e-08 nfin=1
M8 N_M8_d N_M1_d N_M7_d VSS nmos_rvt L=2e-08 W=2.7e-08 nfin=1
M9 VSS N_M9_g N_M8_d VSS nmos_rvt L=2e-08 W=2.7e-08 nfin=1
M10 N_M9_g N_M7_d VSS VSS nmos_rvt L=2e-08 W=2.7e-08 nfin=1
M11 QN N_M7_d VSS VSS nmos_rvt L=2e-08 W=8.1e-08 nfin=3
M12 QN N_M7_d VSS VSS nmos_rvt L=2e-08 W=8.1e-08 nfin=3
M13 QN N_M7_d VSS VSS nmos_rvt L=2e-08 W=8.1e-08 nfin=3
M14 VDD CLK N_M0_s VDD pmos_rvt L=2e-08 W=5.4e-08 nfin=2
M15 N_M1_d N_M0_s VDD VDD pmos_rvt L=2e-08 W=5.4e-08 nfin=2
M16 N_M16_d D VDD VDD pmos_rvt L=2e-08 W=8.1e-08 nfin=3
M17 N_M3_d N_M0_s N_M16_d VDD pmos_rvt L=2e-08 W=8.1e-08 nfin=3
M18 N_M18_d N_M1_d N_M3_d VDD pmos_rvt L=2e-08 W=2.7e-08 nfin=1
M19 VDD N_M5_g N_M18_d VDD pmos_rvt L=2e-08 W=2.7e-08 nfin=1
M20 N_M5_g N_M3_d VDD VDD pmos_rvt L=2e-08 W=2.7e-08 nfin=1
M21 N_M7_d N_M1_d N_M5_g VDD pmos_rvt L=2e-08 W=2.7e-08 nfin=1
M22 N_M22_d N_M0_s N_M7_d VDD pmos_rvt L=2e-08 W=2.7e-08 nfin=1
M23 VDD N_M9_g N_M22_d VDD pmos_rvt L=2e-08 W=2.7e-08 nfin=1
M24 N_M9_g N_M7_d VDD VDD pmos_rvt L=2e-08 W=2.7e-08 nfin=1
M25 QN N_M7_d VDD VDD pmos_rvt L=2e-08 W=8.1e-08 nfin=3
M26 QN N_M7_d VDD VDD pmos_rvt L=2e-08 W=8.1e-08 nfin=3
M27 QN N_M7_d VDD VDD pmos_rvt L=2e-08 W=8.1e-08 nfin=3
.ENDS

.SUBCKT DFFLQx4_ASAP7_75t_R CLK D Q VDD VSS
M0 VSS CLK N_M0_s VSS nmos_rvt L=2e-08 W=5.4e-08 nfin=2
M1 N_M1_d N_M0_s VSS VSS nmos_rvt L=2e-08 W=5.4e-08 nfin=2
M2 N_M2_d D VSS VSS nmos_rvt L=2e-08 W=8.1e-08 nfin=3
M3 N_M3_d N_M1_d N_M2_d VSS nmos_rvt L=2e-08 W=8.1e-08 nfin=3
M4 N_M4_d N_M0_s N_M3_d VSS nmos_rvt L=2e-08 W=2.7e-08 nfin=1
M5 VSS N_M5_g N_M4_d VSS nmos_rvt L=2e-08 W=2.7e-08 nfin=1
M6 N_M5_g N_M3_d VSS VSS nmos_rvt L=2e-08 W=2.7e-08 nfin=1
M7 N_M7_d N_M0_s N_M5_g VSS nmos_rvt L=2e-08 W=2.7e-08 nfin=1
M8 N_M8_d N_M1_d N_M7_d VSS nmos_rvt L=2e-08 W=2.7e-08 nfin=1
M9 VSS N_M9_g N_M8_d VSS nmos_rvt L=2e-08 W=2.7e-08 nfin=1
M10 N_M9_g N_M7_d VSS VSS nmos_rvt L=2e-08 W=2.7e-08 nfin=1
M11 N_M11_d N_M7_d VSS VSS nmos_rvt L=2e-08 W=8.1e-08 nfin=3
M12 N_M11_d N_M7_d VSS VSS nmos_rvt L=2e-08 W=8.1e-08 nfin=3
M13 Q N_M11_d VSS VSS nmos_rvt L=2e-08 W=8.1e-08 nfin=3
M14 Q N_M11_d VSS VSS nmos_rvt L=2e-08 W=8.1e-08 nfin=3
M15 Q N_M11_d VSS VSS nmos_rvt L=2e-08 W=8.1e-08 nfin=3
M16 Q N_M11_d VSS VSS nmos_rvt L=2e-08 W=8.1e-08 nfin=3
M17 VDD CLK N_M0_s VDD pmos_rvt L=2e-08 W=5.4e-08 nfin=2
M18 N_M1_d N_M0_s VDD VDD pmos_rvt L=2e-08 W=5.4e-08 nfin=2
M19 N_M19_d D VDD VDD pmos_rvt L=2e-08 W=8.1e-08 nfin=3
M20 N_M3_d N_M0_s N_M19_d VDD pmos_rvt L=2e-08 W=8.1e-08 nfin=3
M21 N_M21_d N_M1_d N_M3_d VDD pmos_rvt L=2e-08 W=2.7e-08 nfin=1
M22 VDD N_M5_g N_M21_d VDD pmos_rvt L=2e-08 W=2.7e-08 nfin=1
M23 N_M5_g N_M3_d VDD VDD pmos_rvt L=2e-08 W=2.7e-08 nfin=1
M24 N_M7_d N_M1_d N_M5_g VDD pmos_rvt L=2e-08 W=2.7e-08 nfin=1
M25 N_M25_d N_M0_s N_M7_d VDD pmos_rvt L=2e-08 W=2.7e-08 nfin=1
M26 VDD N_M9_g N_M25_d VDD pmos_rvt L=2e-08 W=2.7e-08 nfin=1
M27 N_M9_g N_M7_d VDD VDD pmos_rvt L=2e-08 W=2.7e-08 nfin=1
M28 N_M11_d N_M7_d VDD VDD pmos_rvt L=2e-08 W=8.1e-08 nfin=3
M29 N_M11_d N_M7_d VDD VDD pmos_rvt L=2e-08 W=8.1e-08 nfin=3
M30 Q N_M11_d VDD VDD pmos_rvt L=2e-08 W=8.1e-08 nfin=3
M31 Q N_M11_d VDD VDD pmos_rvt L=2e-08 W=8.1e-08 nfin=3
M32 Q N_M11_d VDD VDD pmos_rvt L=2e-08 W=8.1e-08 nfin=3
M33 Q N_M11_d VDD VDD pmos_rvt L=2e-08 W=8.1e-08 nfin=3
.ENDS

.SUBCKT DHLx1_ASAP7_75t_R CLK D Q VDD VSS
M0 VSS CLK N_M0_s VSS nmos_rvt L=2e-08 W=5.4e-08 nfin=2
M1 N_M1_d N_M0_s VSS VSS nmos_rvt L=2e-08 W=5.4e-08 nfin=2
M2 N_M2_d D VSS VSS nmos_rvt L=2e-08 W=8.1e-08 nfin=3
M3 N_M3_d N_M1_d N_M2_d VSS nmos_rvt L=2e-08 W=8.1e-08 nfin=3
M4 N_M4_d N_M0_s N_M3_d VSS nmos_rvt L=2e-08 W=2.7e-08 nfin=1
M5 VSS N_M5_g N_M4_d VSS nmos_rvt L=2e-08 W=2.7e-08 nfin=1
M6 N_M5_g N_M3_d VSS VSS nmos_rvt L=2e-08 W=2.7e-08 nfin=1
M7 Q N_M3_d VSS VSS nmos_rvt L=2e-08 W=8.1e-08 nfin=3
M8 VDD CLK N_M0_s VDD pmos_rvt L=2e-08 W=5.4e-08 nfin=2
M9 N_M1_d N_M0_s VDD VDD pmos_rvt L=2e-08 W=5.4e-08 nfin=2
M10 N_M10_d D VDD VDD pmos_rvt L=2e-08 W=8.1e-08 nfin=3
M11 N_M3_d N_M0_s N_M10_d VDD pmos_rvt L=2e-08 W=8.1e-08 nfin=3
M12 N_M12_d N_M1_d N_M3_d VDD pmos_rvt L=2e-08 W=2.7e-08 nfin=1
M13 VDD N_M5_g N_M12_d VDD pmos_rvt L=2e-08 W=2.7e-08 nfin=1
M14 N_M5_g N_M3_d VDD VDD pmos_rvt L=2e-08 W=2.7e-08 nfin=1
M15 Q N_M3_d VDD VDD pmos_rvt L=2e-08 W=8.1e-08 nfin=3
.ENDS

.SUBCKT DHLx2_ASAP7_75t_R CLK D Q VDD VSS
M0 VSS CLK N_M0_s VSS nmos_rvt L=2e-08 W=5.4e-08 nfin=2
M1 N_M1_d N_M0_s VSS VSS nmos_rvt L=2e-08 W=5.4e-08 nfin=2
M2 N_M2_d D VSS VSS nmos_rvt L=2e-08 W=8.1e-08 nfin=3
M3 N_M3_d N_M1_d N_M2_d VSS nmos_rvt L=2e-08 W=8.1e-08 nfin=3
M4 N_M4_d N_M0_s N_M3_d VSS nmos_rvt L=2e-08 W=2.7e-08 nfin=1
M5 VSS N_M5_g N_M4_d VSS nmos_rvt L=2e-08 W=2.7e-08 nfin=1
M6 N_M5_g N_M3_d VSS VSS nmos_rvt L=2e-08 W=2.7e-08 nfin=1
M7 Q N_M3_d VSS VSS nmos_rvt L=2e-08 W=8.1e-08 nfin=3
M8 Q N_M3_d VSS VSS nmos_rvt L=2e-08 W=8.1e-08 nfin=3
M9 VDD CLK N_M0_s VDD pmos_rvt L=2e-08 W=5.4e-08 nfin=2
M10 N_M1_d N_M0_s VDD VDD pmos_rvt L=2e-08 W=5.4e-08 nfin=2
M11 N_M11_d D VDD VDD pmos_rvt L=2e-08 W=8.1e-08 nfin=3
M12 N_M3_d N_M0_s N_M11_d VDD pmos_rvt L=2e-08 W=8.1e-08 nfin=3
M13 N_M13_d N_M1_d N_M3_d VDD pmos_rvt L=2e-08 W=2.7e-08 nfin=1
M14 VDD N_M5_g N_M13_d VDD pmos_rvt L=2e-08 W=2.7e-08 nfin=1
M15 N_M5_g N_M3_d VDD VDD pmos_rvt L=2e-08 W=2.7e-08 nfin=1
M16 Q N_M3_d VDD VDD pmos_rvt L=2e-08 W=8.1e-08 nfin=3
M17 Q N_M3_d VDD VDD pmos_rvt L=2e-08 W=8.1e-08 nfin=3
.ENDS

.SUBCKT DHLx3_ASAP7_75t_R CLK D Q VDD VSS
M0 VSS CLK N_M0_s VSS nmos_rvt L=2e-08 W=5.4e-08 nfin=2
M1 N_M1_d N_M0_s VSS VSS nmos_rvt L=2e-08 W=5.4e-08 nfin=2
M2 N_M2_d D VSS VSS nmos_rvt L=2e-08 W=8.1e-08 nfin=3
M3 N_M3_d N_M1_d N_M2_d VSS nmos_rvt L=2e-08 W=8.1e-08 nfin=3
M4 N_M4_d N_M0_s N_M3_d VSS nmos_rvt L=2e-08 W=2.7e-08 nfin=1
M5 VSS N_M5_g N_M4_d VSS nmos_rvt L=2e-08 W=2.7e-08 nfin=1
M6 N_M5_g N_M3_d VSS VSS nmos_rvt L=2e-08 W=2.7e-08 nfin=1
M7 VSS N_M3_d Q VSS nmos_rvt L=2e-08 W=8.1e-08 nfin=3
M8 VSS N_M3_d Q VSS nmos_rvt L=2e-08 W=8.1e-08 nfin=3
M9 VSS N_M3_d Q VSS nmos_rvt L=2e-08 W=8.1e-08 nfin=3
M10 VDD CLK N_M0_s VDD pmos_rvt L=2e-08 W=5.4e-08 nfin=2
M11 N_M1_d N_M0_s VDD VDD pmos_rvt L=2e-08 W=5.4e-08 nfin=2
M12 N_M12_d D VDD VDD pmos_rvt L=2e-08 W=8.1e-08 nfin=3
M13 N_M3_d N_M0_s N_M12_d VDD pmos_rvt L=2e-08 W=8.1e-08 nfin=3
M14 N_M14_d N_M1_d N_M3_d VDD pmos_rvt L=2e-08 W=2.7e-08 nfin=1
M15 VDD N_M5_g N_M14_d VDD pmos_rvt L=2e-08 W=2.7e-08 nfin=1
M16 N_M5_g N_M3_d VDD VDD pmos_rvt L=2e-08 W=2.7e-08 nfin=1
M17 VDD N_M3_d Q VDD pmos_rvt L=2e-08 W=8.1e-08 nfin=3
M18 VDD N_M3_d Q VDD pmos_rvt L=2e-08 W=8.1e-08 nfin=3
M19 VDD N_M3_d Q VDD pmos_rvt L=2e-08 W=8.1e-08 nfin=3
.ENDS

.SUBCKT DLLx1_ASAP7_75t_R CLK D Q VDD VSS
M0 VSS CLK N_M0_s VSS nmos_rvt L=2e-08 W=5.4e-08 nfin=2
M1 N_M1_d N_M0_s VSS VSS nmos_rvt L=2e-08 W=5.4e-08 nfin=2
M2 N_M2_d D VSS VSS nmos_rvt L=2e-08 W=8.1e-08 nfin=3
M3 N_M3_d N_M0_s N_M2_d VSS nmos_rvt L=2e-08 W=8.1e-08 nfin=3
M4 N_M4_d N_M1_d N_M3_d VSS nmos_rvt L=2e-08 W=2.7e-08 nfin=1
M5 VSS N_M5_g N_M4_d VSS nmos_rvt L=2e-08 W=2.7e-08 nfin=1
M6 N_M5_g N_M3_d VSS VSS nmos_rvt L=2e-08 W=2.7e-08 nfin=1
M7 Q N_M3_d VSS VSS nmos_rvt L=2e-08 W=8.1e-08 nfin=3
M8 VDD CLK N_M0_s VDD pmos_rvt L=2e-08 W=5.4e-08 nfin=2
M9 N_M1_d N_M0_s VDD VDD pmos_rvt L=2e-08 W=5.4e-08 nfin=2
M10 N_M10_d D VDD VDD pmos_rvt L=2e-08 W=8.1e-08 nfin=3
M11 N_M3_d N_M1_d N_M10_d VDD pmos_rvt L=2e-08 W=8.1e-08 nfin=3
M12 N_M12_d N_M0_s N_M3_d VDD pmos_rvt L=2e-08 W=2.7e-08 nfin=1
M13 VDD N_M5_g N_M12_d VDD pmos_rvt L=2e-08 W=2.7e-08 nfin=1
M14 N_M5_g N_M3_d VDD VDD pmos_rvt L=2e-08 W=2.7e-08 nfin=1
M15 Q N_M3_d VDD VDD pmos_rvt L=2e-08 W=8.1e-08 nfin=3
.ENDS

.SUBCKT DLLx2_ASAP7_75t_R CLK D Q VDD VSS
M0 VSS CLK N_M0_s VSS nmos_rvt L=2e-08 W=5.4e-08 nfin=2
M1 N_M1_d N_M0_s VSS VSS nmos_rvt L=2e-08 W=5.4e-08 nfin=2
M2 N_M2_d D VSS VSS nmos_rvt L=2e-08 W=8.1e-08 nfin=3
M3 N_M3_d N_M0_s N_M2_d VSS nmos_rvt L=2e-08 W=8.1e-08 nfin=3
M4 N_M4_d N_M1_d N_M3_d VSS nmos_rvt L=2e-08 W=2.7e-08 nfin=1
M5 VSS N_M5_g N_M4_d VSS nmos_rvt L=2e-08 W=2.7e-08 nfin=1
M6 N_M5_g N_M3_d VSS VSS nmos_rvt L=2e-08 W=2.7e-08 nfin=1
M7 VSS N_M3_d Q VSS nmos_rvt L=2e-08 W=8.1e-08 nfin=3
M8 VSS N_M3_d Q VSS nmos_rvt L=2e-08 W=8.1e-08 nfin=3
M9 VDD CLK N_M0_s VDD pmos_rvt L=2e-08 W=5.4e-08 nfin=2
M10 N_M1_d N_M0_s VDD VDD pmos_rvt L=2e-08 W=5.4e-08 nfin=2
M11 N_M11_d D VDD VDD pmos_rvt L=2e-08 W=8.1e-08 nfin=3
M12 N_M3_d N_M1_d N_M11_d VDD pmos_rvt L=2e-08 W=8.1e-08 nfin=3
M13 N_M13_d N_M0_s N_M3_d VDD pmos_rvt L=2e-08 W=2.7e-08 nfin=1
M14 VDD N_M5_g N_M13_d VDD pmos_rvt L=2e-08 W=2.7e-08 nfin=1
M15 N_M5_g N_M3_d VDD VDD pmos_rvt L=2e-08 W=2.7e-08 nfin=1
M16 VDD N_M3_d Q VDD pmos_rvt L=2e-08 W=8.1e-08 nfin=3
M17 VDD N_M3_d Q VDD pmos_rvt L=2e-08 W=8.1e-08 nfin=3
.ENDS

.SUBCKT DLLx3_ASAP7_75t_R CLK D Q VDD VSS
M0 VSS CLK N_M0_s VSS nmos_rvt L=2e-08 W=5.4e-08 nfin=2
M1 N_M1_d N_M0_s VSS VSS nmos_rvt L=2e-08 W=5.4e-08 nfin=2
M2 N_M2_d D VSS VSS nmos_rvt L=2e-08 W=8.1e-08 nfin=3
M3 N_M3_d N_M0_s N_M2_d VSS nmos_rvt L=2e-08 W=8.1e-08 nfin=3
M4 N_M4_d N_M1_d N_M3_d VSS nmos_rvt L=2e-08 W=2.7e-08 nfin=1
M5 VSS N_M5_g N_M4_d VSS nmos_rvt L=2e-08 W=2.7e-08 nfin=1
M6 N_M5_g N_M3_d VSS VSS nmos_rvt L=2e-08 W=2.7e-08 nfin=1
M7 Q N_M3_d VSS VSS nmos_rvt L=2e-08 W=8.1e-08 nfin=3
M8 Q N_M3_d VSS VSS nmos_rvt L=2e-08 W=8.1e-08 nfin=3
M9 Q N_M3_d VSS VSS nmos_rvt L=2e-08 W=8.1e-08 nfin=3
M10 VDD CLK N_M0_s VDD pmos_rvt L=2e-08 W=5.4e-08 nfin=2
M11 N_M1_d N_M0_s VDD VDD pmos_rvt L=2e-08 W=5.4e-08 nfin=2
M12 N_M12_d D VDD VDD pmos_rvt L=2e-08 W=8.1e-08 nfin=3
M13 N_M3_d N_M1_d N_M12_d VDD pmos_rvt L=2e-08 W=8.1e-08 nfin=3
M14 N_M14_d N_M0_s N_M3_d VDD pmos_rvt L=2e-08 W=2.7e-08 nfin=1
M15 VDD N_M5_g N_M14_d VDD pmos_rvt L=2e-08 W=2.7e-08 nfin=1
M16 N_M5_g N_M3_d VDD VDD pmos_rvt L=2e-08 W=2.7e-08 nfin=1
M17 Q N_M3_d VDD VDD pmos_rvt L=2e-08 W=8.1e-08 nfin=3
M18 Q N_M3_d VDD VDD pmos_rvt L=2e-08 W=8.1e-08 nfin=3
M19 Q N_M3_d VDD VDD pmos_rvt L=2e-08 W=8.1e-08 nfin=3
.ENDS

.SUBCKT FAx1_ASAP7_75t_R A B CI CON SN VDD VSS
M0 VSS A N_M0_s VSS nmos_rvt L=2e-08 W=8.1e-08 nfin=3
M1 N_M1_d A VSS VSS nmos_rvt L=2e-08 W=8.1e-08 nfin=3
M2 CON B N_M1_d VSS nmos_rvt L=2e-08 W=8.1e-08 nfin=3
M3 N_M0_s CI CON VSS nmos_rvt L=2e-08 W=8.1e-08 nfin=3
M4 VSS B N_M0_s VSS nmos_rvt L=2e-08 W=8.1e-08 nfin=3
M5 N_M5_d B VSS VSS nmos_rvt L=2e-08 W=8.1e-08 nfin=3
M6 N_M6_d A N_M5_d VSS nmos_rvt L=2e-08 W=8.1e-08 nfin=3
M7 SN CI N_M6_d VSS nmos_rvt L=2e-08 W=8.1e-08 nfin=3
M8 N_M8_d CON SN VSS nmos_rvt L=2e-08 W=8.1e-08 nfin=3
M9 VSS CI N_M8_d VSS nmos_rvt L=2e-08 W=8.1e-08 nfin=3
M10 N_M8_d A VSS VSS nmos_rvt L=2e-08 W=8.1e-08 nfin=3
M11 VSS B N_M8_d VSS nmos_rvt L=2e-08 W=8.1e-08 nfin=3
M12 VDD A N_M12_s VDD pmos_rvt L=2e-08 W=8.1e-08 nfin=3
M13 N_M13_d A VDD VDD pmos_rvt L=2e-08 W=8.1e-08 nfin=3
M14 CON B N_M13_d VDD pmos_rvt L=2e-08 W=8.1e-08 nfin=3
M15 N_M12_s CI CON VDD pmos_rvt L=2e-08 W=8.1e-08 nfin=3
M16 VDD B N_M12_s VDD pmos_rvt L=2e-08 W=8.1e-08 nfin=3
M17 N_M17_d B VDD VDD pmos_rvt L=2e-08 W=8.1e-08 nfin=3
M18 N_M18_d A N_M17_d VDD pmos_rvt L=2e-08 W=8.1e-08 nfin=3
M19 SN CI N_M18_d VDD pmos_rvt L=2e-08 W=8.1e-08 nfin=3
M20 N_M20_d CON SN VDD pmos_rvt L=2e-08 W=8.1e-08 nfin=3
M21 VDD CI N_M20_d VDD pmos_rvt L=2e-08 W=8.1e-08 nfin=3
M22 N_M20_d A VDD VDD pmos_rvt L=2e-08 W=8.1e-08 nfin=3
M23 VDD B N_M20_d VDD pmos_rvt L=2e-08 W=8.1e-08 nfin=3
.ENDS

.SUBCKT HAxp5_ASAP7_75t_R A B CON SN VDD VSS
M0 N_M0_d A VSS VSS nmos_rvt L=2e-08 W=8.1e-08 nfin=3
M1 CON B N_M0_d VSS nmos_rvt L=2e-08 W=8.1e-08 nfin=3
M2 VSS B noxref_6 VSS nmos_rvt L=2e-08 W=8.1e-08 nfin=3
M3 noxref_6 A VSS VSS nmos_rvt L=2e-08 W=8.1e-08 nfin=3
M4 SN CON noxref_6 VSS nmos_rvt L=2e-08 W=8.1e-08 nfin=3
M5 CON A VDD VDD pmos_rvt L=2e-08 W=5.4e-08 nfin=2
M6 VDD B CON VDD pmos_rvt L=2e-08 W=5.4e-08 nfin=2
M7 noxref_9 B SN VDD pmos_rvt L=2e-08 W=8.1e-08 nfin=3
M8 VDD A noxref_9 VDD pmos_rvt L=2e-08 W=8.1e-08 nfin=3
M9 SN CON VDD VDD pmos_rvt L=2e-08 W=8.1e-08 nfin=3
.ENDS

.SUBCKT HB1xp67_ASAP7_75t_R A VDD VSS Y
M0 VSS A N_M0_s VSS nmos_rvt L=2e-08 W=2.7e-08 nfin=1
M1 Y N_M0_s VSS VSS nmos_rvt L=2e-08 W=5.4e-08 nfin=2
M2 VDD A N_M0_s VDD pmos_rvt L=2e-08 W=2.7e-08 nfin=1
M3 Y N_M0_s VDD VDD pmos_rvt L=2e-08 W=5.4e-08 nfin=2
.ENDS

.SUBCKT HB2xp67_ASAP7_75t_R A VDD VSS Y
M0 N_M0_d A N_M0_s VSS nmos_rvt L=2e-08 W=2.7e-08 nfin=1
M1 VSS A N_M0_d VSS nmos_rvt L=2e-08 W=2.7e-08 nfin=1
M2 Y N_M0_s VSS VSS nmos_rvt L=2e-08 W=5.4e-08 nfin=2
M3 N_M3_d A N_M0_s VDD pmos_rvt L=2e-08 W=2.7e-08 nfin=1
M4 VDD A N_M3_d VDD pmos_rvt L=2e-08 W=2.7e-08 nfin=1
M5 Y N_M0_s VDD VDD pmos_rvt L=2e-08 W=5.4e-08 nfin=2
.ENDS

.SUBCKT HB3xp67_ASAP7_75t_R A VDD VSS Y
M0 N_M0_d A N_M0_s VSS nmos_rvt L=2e-08 W=2.7e-08 nfin=1
M1 N_M1_d A N_M0_d VSS nmos_rvt L=2e-08 W=2.7e-08 nfin=1
M2 VSS A N_M1_d VSS nmos_rvt L=2e-08 W=2.7e-08 nfin=1
M3 Y N_M0_s VSS VSS nmos_rvt L=2e-08 W=5.4e-08 nfin=2
M4 N_M4_d A N_M0_s VDD pmos_rvt L=2e-08 W=2.7e-08 nfin=1
M5 N_M5_d A N_M4_d VDD pmos_rvt L=2e-08 W=2.7e-08 nfin=1
M6 VDD A N_M5_d VDD pmos_rvt L=2e-08 W=2.7e-08 nfin=1
M7 Y N_M0_s VDD VDD pmos_rvt L=2e-08 W=5.4e-08 nfin=2
.ENDS

.SUBCKT HB4xp67_ASAP7_75t_R A VDD VSS Y
M0 N_M0_d A N_M0_s VSS nmos_rvt L=2e-08 W=2.7e-08 nfin=1
M1 N_M1_d A N_M0_d VSS nmos_rvt L=2e-08 W=2.7e-08 nfin=1
M2 N_M2_d A N_M1_d VSS nmos_rvt L=2e-08 W=2.7e-08 nfin=1
M3 VSS A N_M2_d VSS nmos_rvt L=2e-08 W=2.7e-08 nfin=1
M4 Y N_M0_s VSS VSS nmos_rvt L=2e-08 W=5.4e-08 nfin=2
M5 N_M5_d A N_M0_s VDD pmos_rvt L=2e-08 W=2.7e-08 nfin=1
M6 N_M6_d A N_M5_d VDD pmos_rvt L=2e-08 W=2.7e-08 nfin=1
M7 N_M7_d A N_M6_d VDD pmos_rvt L=2e-08 W=2.7e-08 nfin=1
M8 VDD A N_M7_d VDD pmos_rvt L=2e-08 W=2.7e-08 nfin=1
M9 Y N_M0_s VDD VDD pmos_rvt L=2e-08 W=5.4e-08 nfin=2
.ENDS

.SUBCKT ICGx1_ASAP7_75t_R CLK ENA GCLK SE VDD VSS
M0 N_M0_d ENA VSS VSS nmos_rvt L=2e-08 W=5.4e-08 nfin=2
M1 VSS SE N_M0_d VSS nmos_rvt L=2e-08 W=5.4e-08 nfin=2
M2 N_M2_d N_M0_d VSS VSS nmos_rvt L=2e-08 W=8.1e-08 nfin=3
M3 N_M3_d N_M3_g N_M2_d VSS nmos_rvt L=2e-08 W=8.1e-08 nfin=3
M4 N_M4_d CLK N_M3_d VSS nmos_rvt L=2e-08 W=2.7e-08 nfin=1
M5 VSS N_M5_g N_M4_d VSS nmos_rvt L=2e-08 W=2.7e-08 nfin=1
M6 N_M5_g N_M3_d VSS VSS nmos_rvt L=2e-08 W=2.7e-08 nfin=1
M7 VSS CLK N_M3_g VSS nmos_rvt L=2e-08 W=8.1e-08 nfin=3
M8 VSS N_M3_d N_M8_s VSS nmos_rvt L=2e-08 W=8.1e-08 nfin=3
M9 N_M8_s CLK N_M9_s VSS nmos_rvt L=2e-08 W=8.1e-08 nfin=3
M10 N_M10_d CLK N_M9_s VSS nmos_rvt L=2e-08 W=8.1e-08 nfin=3
M11 VSS N_M3_d N_M10_d VSS nmos_rvt L=2e-08 W=8.1e-08 nfin=3
M12 GCLK N_M9_s VSS VSS nmos_rvt L=2e-08 W=8.1e-08 nfin=3
M13 N_M13_d ENA N_M0_d VDD pmos_rvt L=2e-08 W=5.4e-08 nfin=2
M14 VDD SE N_M13_d VDD pmos_rvt L=2e-08 W=5.4e-08 nfin=2
M15 N_M15_d N_M0_d VDD VDD pmos_rvt L=2e-08 W=8.1e-08 nfin=3
M16 N_M3_d CLK N_M15_d VDD pmos_rvt L=2e-08 W=8.1e-08 nfin=3
M17 N_M17_d N_M3_g N_M3_d VDD pmos_rvt L=2e-08 W=2.7e-08 nfin=1
M18 VDD N_M5_g N_M17_d VDD pmos_rvt L=2e-08 W=2.7e-08 nfin=1
M19 N_M5_g N_M3_d VDD VDD pmos_rvt L=2e-08 W=2.7e-08 nfin=1
M20 VDD CLK N_M3_g VDD pmos_rvt L=2e-08 W=8.1e-08 nfin=3
M21 N_M9_s N_M3_d VDD VDD pmos_rvt L=2e-08 W=5.4e-08 nfin=2
M22 VDD CLK N_M9_s VDD pmos_rvt L=2e-08 W=5.4e-08 nfin=2
M23 VDD CLK N_M9_s VDD pmos_rvt L=2e-08 W=5.4e-08 nfin=2
M24 N_M9_s N_M3_d VDD VDD pmos_rvt L=2e-08 W=5.4e-08 nfin=2
M25 GCLK N_M9_s VDD VDD pmos_rvt L=2e-08 W=8.1e-08 nfin=3
.ENDS

.SUBCKT ICGx2_ASAP7_75t_R CLK ENA GCLK SE VDD VSS
M0 N_M0_d ENA VSS VSS nmos_rvt L=2e-08 W=5.4e-08 nfin=2
M1 VSS SE N_M0_d VSS nmos_rvt L=2e-08 W=5.4e-08 nfin=2
M2 N_M2_d N_M0_d VSS VSS nmos_rvt L=2e-08 W=8.1e-08 nfin=3
M3 N_M3_d N_M3_g N_M2_d VSS nmos_rvt L=2e-08 W=8.1e-08 nfin=3
M4 N_M4_d CLK N_M3_d VSS nmos_rvt L=2e-08 W=2.7e-08 nfin=1
M5 VSS N_M5_g N_M4_d VSS nmos_rvt L=2e-08 W=2.7e-08 nfin=1
M6 N_M5_g N_M3_d VSS VSS nmos_rvt L=2e-08 W=2.7e-08 nfin=1
M7 VSS CLK N_M3_g VSS nmos_rvt L=2e-08 W=8.1e-08 nfin=3
M8 VSS N_M3_d N_M8_s VSS nmos_rvt L=2e-08 W=8.1e-08 nfin=3
M9 N_M8_s CLK N_M9_s VSS nmos_rvt L=2e-08 W=8.1e-08 nfin=3
M10 N_M10_d CLK N_M9_s VSS nmos_rvt L=2e-08 W=8.1e-08 nfin=3
M11 VSS N_M3_d N_M10_d VSS nmos_rvt L=2e-08 W=8.1e-08 nfin=3
M12 GCLK N_M9_s VSS VSS nmos_rvt L=2e-08 W=8.1e-08 nfin=3
M13 GCLK N_M9_s VSS VSS nmos_rvt L=2e-08 W=8.1e-08 nfin=3
M14 N_M14_d ENA N_M0_d VDD pmos_rvt L=2e-08 W=5.4e-08 nfin=2
M15 VDD SE N_M14_d VDD pmos_rvt L=2e-08 W=5.4e-08 nfin=2
M16 N_M16_d N_M0_d VDD VDD pmos_rvt L=2e-08 W=8.1e-08 nfin=3
M17 N_M3_d CLK N_M16_d VDD pmos_rvt L=2e-08 W=8.1e-08 nfin=3
M18 N_M18_d N_M3_g N_M3_d VDD pmos_rvt L=2e-08 W=2.7e-08 nfin=1
M19 VDD N_M5_g N_M18_d VDD pmos_rvt L=2e-08 W=2.7e-08 nfin=1
M20 N_M5_g N_M3_d VDD VDD pmos_rvt L=2e-08 W=2.7e-08 nfin=1
M21 VDD CLK N_M3_g VDD pmos_rvt L=2e-08 W=8.1e-08 nfin=3
M22 N_M9_s N_M3_d VDD VDD pmos_rvt L=2e-08 W=5.4e-08 nfin=2
M23 VDD CLK N_M9_s VDD pmos_rvt L=2e-08 W=5.4e-08 nfin=2
M24 VDD CLK N_M9_s VDD pmos_rvt L=2e-08 W=5.4e-08 nfin=2
M25 N_M9_s N_M3_d VDD VDD pmos_rvt L=2e-08 W=5.4e-08 nfin=2
M26 GCLK N_M9_s VDD VDD pmos_rvt L=2e-08 W=8.1e-08 nfin=3
M27 GCLK N_M9_s VDD VDD pmos_rvt L=2e-08 W=8.1e-08 nfin=3
.ENDS

.SUBCKT ICGx2p67DC_ASAP7_75t_R CLK ENA GCLK SE VDD VSS
M0 GCLK N_M0_g VSS VSS nmos_rvt L=2e-08 W=2.7e-08 nfin=1
M1 GCLK N_M0_g VSS VSS nmos_rvt L=2e-08 W=2.7e-08 nfin=1
M2 VSS N_M2_g N_M2_s VSS nmos_rvt L=2e-08 W=8.1e-08 nfin=3
M3 N_M2_s CLK N_M0_g VSS nmos_rvt L=2e-08 W=8.1e-08 nfin=3
M4 N_M4_d CLK N_M0_g VSS nmos_rvt L=2e-08 W=8.1e-08 nfin=3
M5 VSS N_M2_g N_M4_d VSS nmos_rvt L=2e-08 W=8.1e-08 nfin=3
M6 N_M6_d N_M6_d VSS VSS nmos_rvt L=2e-08 W=8.1e-08 nfin=3
M7 N_M6_d N_M6_d VSS VSS nmos_rvt L=2e-08 W=8.1e-08 nfin=3
M8 N_M6_d N_M8_g VSS VSS nmos_rvt L=2e-08 W=8.1e-08 nfin=3
M9 N_M6_d N_M8_g VSS VSS nmos_rvt L=2e-08 W=8.1e-08 nfin=3
M10 GCLK N_M10_g VSS VSS nmos_rvt L=2e-08 W=2.7e-08 nfin=1
M11 GCLK N_M10_g VSS VSS nmos_rvt L=2e-08 W=2.7e-08 nfin=1
M12 VSS N_M2_g N_M12_s VSS nmos_rvt L=2e-08 W=8.1e-08 nfin=3
M13 N_M12_s CLK N_M10_g VSS nmos_rvt L=2e-08 W=8.1e-08 nfin=3
M14 N_M14_d CLK N_M10_g VSS nmos_rvt L=2e-08 W=8.1e-08 nfin=3
M15 VSS N_M2_g N_M14_d VSS nmos_rvt L=2e-08 W=8.1e-08 nfin=3
M16 N_M16_d CLK VSS VSS nmos_rvt L=2e-08 W=8.1e-08 nfin=3
M17 N_M17_d ENA VSS VSS nmos_rvt L=2e-08 W=5.4e-08 nfin=2
M18 VSS SE N_M17_d VSS nmos_rvt L=2e-08 W=5.4e-08 nfin=2
M19 N_M19_d N_M17_d VSS VSS nmos_rvt L=2e-08 W=8.1e-08 nfin=3
M20 N_M2_g N_M16_d N_M19_d VSS nmos_rvt L=2e-08 W=8.1e-08 nfin=3
M21 N_M21_d CLK N_M2_g VSS nmos_rvt L=2e-08 W=2.7e-08 nfin=1
M22 VSS N_M22_g N_M21_d VSS nmos_rvt L=2e-08 W=2.7e-08 nfin=1
M23 N_M22_g N_M2_g VSS VSS nmos_rvt L=2e-08 W=2.7e-08 nfin=1
M24 N_M16_d CLK VSS VSS nmos_rvt L=2e-08 W=8.1e-08 nfin=3
M25 VSS N_M2_g N_M25_s VSS nmos_rvt L=2e-08 W=8.1e-08 nfin=3
M26 N_M25_s CLK N_M26_s VSS nmos_rvt L=2e-08 W=8.1e-08 nfin=3
M27 N_M27_d CLK N_M26_s VSS nmos_rvt L=2e-08 W=8.1e-08 nfin=3
M28 VSS N_M2_g N_M27_d VSS nmos_rvt L=2e-08 W=8.1e-08 nfin=3
M29 GCLK N_M26_s VSS VSS nmos_rvt L=2e-08 W=2.7e-08 nfin=1
M30 GCLK N_M26_s VSS VSS nmos_rvt L=2e-08 W=2.7e-08 nfin=1
M31 N_M31_d N_M31_g VSS VSS nmos_rvt L=2e-08 W=8.1e-08 nfin=3
M32 N_M31_d N_M31_g VSS VSS nmos_rvt L=2e-08 W=8.1e-08 nfin=3
M33 N_M31_d N_M31_d VSS VSS nmos_rvt L=2e-08 W=8.1e-08 nfin=3
M34 N_M31_d N_M31_d VSS VSS nmos_rvt L=2e-08 W=8.1e-08 nfin=3
M35 VSS N_M2_g N_M35_s VSS nmos_rvt L=2e-08 W=8.1e-08 nfin=3
M36 N_M35_s CLK N_M36_s VSS nmos_rvt L=2e-08 W=8.1e-08 nfin=3
M37 N_M37_d CLK N_M36_s VSS nmos_rvt L=2e-08 W=8.1e-08 nfin=3
M38 VSS N_M2_g N_M37_d VSS nmos_rvt L=2e-08 W=8.1e-08 nfin=3
M39 GCLK N_M36_s VSS VSS nmos_rvt L=2e-08 W=2.7e-08 nfin=1
M40 GCLK N_M36_s VSS VSS nmos_rvt L=2e-08 W=2.7e-08 nfin=1
M41 GCLK N_M0_g VDD VDD pmos_rvt L=2e-08 W=2.7e-08 nfin=1
M42 GCLK N_M0_g VDD VDD pmos_rvt L=2e-08 W=2.7e-08 nfin=1
M43 N_M0_g N_M2_g VDD VDD pmos_rvt L=2e-08 W=5.4e-08 nfin=2
M44 VDD CLK N_M0_g VDD pmos_rvt L=2e-08 W=5.4e-08 nfin=2
M45 VDD CLK N_M0_g VDD pmos_rvt L=2e-08 W=5.4e-08 nfin=2
M46 N_M0_g N_M2_g VDD VDD pmos_rvt L=2e-08 W=5.4e-08 nfin=2
M47 N_M8_g N_M6_d VDD VDD pmos_rvt L=2e-08 W=8.1e-08 nfin=3
M48 N_M8_g N_M6_d VDD VDD pmos_rvt L=2e-08 W=8.1e-08 nfin=3
M49 N_M8_g N_M8_g VDD VDD pmos_rvt L=2e-08 W=8.1e-08 nfin=3
M50 N_M8_g N_M8_g VDD VDD pmos_rvt L=2e-08 W=8.1e-08 nfin=3
M51 GCLK N_M10_g VDD VDD pmos_rvt L=2e-08 W=2.7e-08 nfin=1
M52 GCLK N_M10_g VDD VDD pmos_rvt L=2e-08 W=2.7e-08 nfin=1
M53 N_M10_g N_M2_g VDD VDD pmos_rvt L=2e-08 W=5.4e-08 nfin=2
M54 VDD CLK N_M10_g VDD pmos_rvt L=2e-08 W=5.4e-08 nfin=2
M55 VDD CLK N_M10_g VDD pmos_rvt L=2e-08 W=5.4e-08 nfin=2
M56 N_M10_g N_M2_g VDD VDD pmos_rvt L=2e-08 W=5.4e-08 nfin=2
M57 N_M16_d CLK VDD VDD pmos_rvt L=2e-08 W=8.1e-08 nfin=3
M58 N_M58_d ENA N_M17_d VDD pmos_rvt L=2e-08 W=5.4e-08 nfin=2
M59 VDD SE N_M58_d VDD pmos_rvt L=2e-08 W=5.4e-08 nfin=2
M60 N_M60_d N_M17_d VDD VDD pmos_rvt L=2e-08 W=8.1e-08 nfin=3
M61 N_M2_g CLK N_M60_d VDD pmos_rvt L=2e-08 W=8.1e-08 nfin=3
M62 N_M62_d N_M16_d N_M2_g VDD pmos_rvt L=2e-08 W=2.7e-08 nfin=1
M63 VDD N_M22_g N_M62_d VDD pmos_rvt L=2e-08 W=2.7e-08 nfin=1
M64 N_M22_g N_M2_g VDD VDD pmos_rvt L=2e-08 W=2.7e-08 nfin=1
M65 N_M16_d CLK VDD VDD pmos_rvt L=2e-08 W=8.1e-08 nfin=3
M66 N_M26_s N_M2_g VDD VDD pmos_rvt L=2e-08 W=5.4e-08 nfin=2
M67 VDD CLK N_M26_s VDD pmos_rvt L=2e-08 W=5.4e-08 nfin=2
M68 VDD CLK N_M26_s VDD pmos_rvt L=2e-08 W=5.4e-08 nfin=2
M69 N_M26_s N_M2_g VDD VDD pmos_rvt L=2e-08 W=5.4e-08 nfin=2
M70 GCLK N_M26_s VDD VDD pmos_rvt L=2e-08 W=2.7e-08 nfin=1
M71 GCLK N_M26_s VDD VDD pmos_rvt L=2e-08 W=2.7e-08 nfin=1
M72 N_M31_g N_M31_g VDD VDD pmos_rvt L=2e-08 W=8.1e-08 nfin=3
M73 N_M31_g N_M31_g VDD VDD pmos_rvt L=2e-08 W=8.1e-08 nfin=3
M74 N_M31_g N_M31_d VDD VDD pmos_rvt L=2e-08 W=8.1e-08 nfin=3
M75 N_M31_g N_M31_d VDD VDD pmos_rvt L=2e-08 W=8.1e-08 nfin=3
M76 N_M36_s N_M2_g VDD VDD pmos_rvt L=2e-08 W=5.4e-08 nfin=2
M77 VDD CLK N_M36_s VDD pmos_rvt L=2e-08 W=5.4e-08 nfin=2
M78 VDD CLK N_M36_s VDD pmos_rvt L=2e-08 W=5.4e-08 nfin=2
M79 N_M36_s N_M2_g VDD VDD pmos_rvt L=2e-08 W=5.4e-08 nfin=2
M80 GCLK N_M36_s VDD VDD pmos_rvt L=2e-08 W=2.7e-08 nfin=1
M81 GCLK N_M36_s VDD VDD pmos_rvt L=2e-08 W=2.7e-08 nfin=1
.ENDS

.SUBCKT ICGx3_ASAP7_75t_R CLK ENA GCLK SE VDD VSS
M0 N_M0_d ENA VSS VSS nmos_rvt L=2e-08 W=5.4e-08 nfin=2
M1 VSS SE N_M0_d VSS nmos_rvt L=2e-08 W=5.4e-08 nfin=2
M2 N_M2_d N_M0_d VSS VSS nmos_rvt L=2e-08 W=8.1e-08 nfin=3
M3 N_M3_d N_M3_g N_M2_d VSS nmos_rvt L=2e-08 W=8.1e-08 nfin=3
M4 N_M4_d CLK N_M3_d VSS nmos_rvt L=2e-08 W=2.7e-08 nfin=1
M5 VSS N_M5_g N_M4_d VSS nmos_rvt L=2e-08 W=2.7e-08 nfin=1
M6 N_M5_g N_M3_d VSS VSS nmos_rvt L=2e-08 W=2.7e-08 nfin=1
M7 VSS CLK N_M3_g VSS nmos_rvt L=2e-08 W=8.1e-08 nfin=3
M8 VSS N_M3_d N_M8_s VSS nmos_rvt L=2e-08 W=8.1e-08 nfin=3
M9 N_M8_s CLK N_M9_s VSS nmos_rvt L=2e-08 W=8.1e-08 nfin=3
M10 N_M10_d CLK N_M9_s VSS nmos_rvt L=2e-08 W=8.1e-08 nfin=3
M11 VSS N_M3_d N_M10_d VSS nmos_rvt L=2e-08 W=8.1e-08 nfin=3
M12 GCLK N_M9_s VSS VSS nmos_rvt L=2e-08 W=8.1e-08 nfin=3
M13 GCLK N_M9_s VSS VSS nmos_rvt L=2e-08 W=8.1e-08 nfin=3
M14 GCLK N_M9_s VSS VSS nmos_rvt L=2e-08 W=8.1e-08 nfin=3
M15 N_M15_d ENA N_M0_d VDD pmos_rvt L=2e-08 W=5.4e-08 nfin=2
M16 VDD SE N_M15_d VDD pmos_rvt L=2e-08 W=5.4e-08 nfin=2
M17 N_M17_d N_M0_d VDD VDD pmos_rvt L=2e-08 W=8.1e-08 nfin=3
M18 N_M3_d CLK N_M17_d VDD pmos_rvt L=2e-08 W=8.1e-08 nfin=3
M19 N_M19_d N_M3_g N_M3_d VDD pmos_rvt L=2e-08 W=2.7e-08 nfin=1
M20 VDD N_M5_g N_M19_d VDD pmos_rvt L=2e-08 W=2.7e-08 nfin=1
M21 N_M5_g N_M3_d VDD VDD pmos_rvt L=2e-08 W=2.7e-08 nfin=1
M22 VDD CLK N_M3_g VDD pmos_rvt L=2e-08 W=8.1e-08 nfin=3
M23 N_M9_s N_M3_d VDD VDD pmos_rvt L=2e-08 W=5.4e-08 nfin=2
M24 VDD CLK N_M9_s VDD pmos_rvt L=2e-08 W=5.4e-08 nfin=2
M25 VDD CLK N_M9_s VDD pmos_rvt L=2e-08 W=5.4e-08 nfin=2
M26 N_M9_s N_M3_d VDD VDD pmos_rvt L=2e-08 W=5.4e-08 nfin=2
M27 GCLK N_M9_s VDD VDD pmos_rvt L=2e-08 W=8.1e-08 nfin=3
M28 GCLK N_M9_s VDD VDD pmos_rvt L=2e-08 W=8.1e-08 nfin=3
M29 GCLK N_M9_s VDD VDD pmos_rvt L=2e-08 W=8.1e-08 nfin=3
.ENDS

.SUBCKT ICGx4DC_ASAP7_75t_R CLK ENA GCLK SE VDD VSS
M0 GCLK N_M0_g VSS VSS nmos_rvt L=2e-08 W=2.7e-08 nfin=1
M1 GCLK N_M0_g VSS VSS nmos_rvt L=2e-08 W=2.7e-08 nfin=1
M2 VSS N_M2_g N_M2_s VSS nmos_rvt L=2e-08 W=8.1e-08 nfin=3
M3 N_M2_s CLK N_M0_g VSS nmos_rvt L=2e-08 W=8.1e-08 nfin=3
M4 N_M4_d CLK N_M0_g VSS nmos_rvt L=2e-08 W=8.1e-08 nfin=3
M5 VSS N_M2_g N_M4_d VSS nmos_rvt L=2e-08 W=8.1e-08 nfin=3
M6 N_M6_d N_M6_d VSS VSS nmos_rvt L=2e-08 W=8.1e-08 nfin=3
M7 N_M6_d N_M6_d VSS VSS nmos_rvt L=2e-08 W=8.1e-08 nfin=3
M8 N_M6_d N_M8_g VSS VSS nmos_rvt L=2e-08 W=8.1e-08 nfin=3
M9 N_M6_d N_M8_g VSS VSS nmos_rvt L=2e-08 W=8.1e-08 nfin=3
M10 GCLK N_M10_g VSS VSS nmos_rvt L=2e-08 W=5.4e-08 nfin=2
M11 GCLK N_M10_g VSS VSS nmos_rvt L=2e-08 W=5.4e-08 nfin=2
M12 VSS N_M2_g N_M12_s VSS nmos_rvt L=2e-08 W=8.1e-08 nfin=3
M13 N_M12_s CLK N_M10_g VSS nmos_rvt L=2e-08 W=8.1e-08 nfin=3
M14 N_M14_d CLK N_M10_g VSS nmos_rvt L=2e-08 W=8.1e-08 nfin=3
M15 VSS N_M2_g N_M14_d VSS nmos_rvt L=2e-08 W=8.1e-08 nfin=3
M16 N_M16_d CLK VSS VSS nmos_rvt L=2e-08 W=8.1e-08 nfin=3
M17 N_M17_d ENA VSS VSS nmos_rvt L=2e-08 W=5.4e-08 nfin=2
M18 VSS SE N_M17_d VSS nmos_rvt L=2e-08 W=5.4e-08 nfin=2
M19 N_M19_d N_M17_d VSS VSS nmos_rvt L=2e-08 W=8.1e-08 nfin=3
M20 N_M2_g N_M16_d N_M19_d VSS nmos_rvt L=2e-08 W=8.1e-08 nfin=3
M21 N_M21_d CLK N_M2_g VSS nmos_rvt L=2e-08 W=2.7e-08 nfin=1
M22 VSS N_M22_g N_M21_d VSS nmos_rvt L=2e-08 W=2.7e-08 nfin=1
M23 N_M22_g N_M2_g VSS VSS nmos_rvt L=2e-08 W=2.7e-08 nfin=1
M24 N_M16_d CLK VSS VSS nmos_rvt L=2e-08 W=8.1e-08 nfin=3
M25 VSS N_M2_g N_M25_s VSS nmos_rvt L=2e-08 W=8.1e-08 nfin=3
M26 N_M25_s CLK N_M26_s VSS nmos_rvt L=2e-08 W=8.1e-08 nfin=3
M27 N_M27_d CLK N_M26_s VSS nmos_rvt L=2e-08 W=8.1e-08 nfin=3
M28 VSS N_M2_g N_M27_d VSS nmos_rvt L=2e-08 W=8.1e-08 nfin=3
M29 GCLK N_M26_s VSS VSS nmos_rvt L=2e-08 W=5.4e-08 nfin=2
M30 GCLK N_M26_s VSS VSS nmos_rvt L=2e-08 W=5.4e-08 nfin=2
M31 N_M31_d N_M31_g VSS VSS nmos_rvt L=2e-08 W=8.1e-08 nfin=3
M32 N_M31_d N_M31_g VSS VSS nmos_rvt L=2e-08 W=8.1e-08 nfin=3
M33 N_M31_d N_M31_d VSS VSS nmos_rvt L=2e-08 W=8.1e-08 nfin=3
M34 N_M31_d N_M31_d VSS VSS nmos_rvt L=2e-08 W=8.1e-08 nfin=3
M35 VSS N_M2_g N_M35_s VSS nmos_rvt L=2e-08 W=8.1e-08 nfin=3
M36 N_M35_s CLK N_M36_s VSS nmos_rvt L=2e-08 W=8.1e-08 nfin=3
M37 N_M37_d CLK N_M36_s VSS nmos_rvt L=2e-08 W=8.1e-08 nfin=3
M38 VSS N_M2_g N_M37_d VSS nmos_rvt L=2e-08 W=8.1e-08 nfin=3
M39 GCLK N_M36_s VSS VSS nmos_rvt L=2e-08 W=2.7e-08 nfin=1
M40 GCLK N_M36_s VSS VSS nmos_rvt L=2e-08 W=2.7e-08 nfin=1
M41 GCLK N_M0_g VDD VDD pmos_rvt L=2e-08 W=2.7e-08 nfin=1
M42 GCLK N_M0_g VDD VDD pmos_rvt L=2e-08 W=2.7e-08 nfin=1
M43 N_M0_g N_M2_g VDD VDD pmos_rvt L=2e-08 W=5.4e-08 nfin=2
M44 VDD CLK N_M0_g VDD pmos_rvt L=2e-08 W=5.4e-08 nfin=2
M45 VDD CLK N_M0_g VDD pmos_rvt L=2e-08 W=5.4e-08 nfin=2
M46 N_M0_g N_M2_g VDD VDD pmos_rvt L=2e-08 W=5.4e-08 nfin=2
M47 N_M8_g N_M6_d VDD VDD pmos_rvt L=2e-08 W=8.1e-08 nfin=3
M48 N_M8_g N_M6_d VDD VDD pmos_rvt L=2e-08 W=8.1e-08 nfin=3
M49 N_M8_g N_M8_g VDD VDD pmos_rvt L=2e-08 W=8.1e-08 nfin=3
M50 N_M8_g N_M8_g VDD VDD pmos_rvt L=2e-08 W=8.1e-08 nfin=3
M51 GCLK N_M10_g VDD VDD pmos_rvt L=2e-08 W=5.4e-08 nfin=2
M52 GCLK N_M10_g VDD VDD pmos_rvt L=2e-08 W=5.4e-08 nfin=2
M53 N_M10_g N_M2_g VDD VDD pmos_rvt L=2e-08 W=5.4e-08 nfin=2
M54 VDD CLK N_M10_g VDD pmos_rvt L=2e-08 W=5.4e-08 nfin=2
M55 VDD CLK N_M10_g VDD pmos_rvt L=2e-08 W=5.4e-08 nfin=2
M56 N_M10_g N_M2_g VDD VDD pmos_rvt L=2e-08 W=5.4e-08 nfin=2
M57 N_M16_d CLK VDD VDD pmos_rvt L=2e-08 W=8.1e-08 nfin=3
M58 N_M58_d ENA N_M17_d VDD pmos_rvt L=2e-08 W=5.4e-08 nfin=2
M59 VDD SE N_M58_d VDD pmos_rvt L=2e-08 W=5.4e-08 nfin=2
M60 N_M60_d N_M17_d VDD VDD pmos_rvt L=2e-08 W=8.1e-08 nfin=3
M61 N_M2_g CLK N_M60_d VDD pmos_rvt L=2e-08 W=8.1e-08 nfin=3
M62 N_M62_d N_M16_d N_M2_g VDD pmos_rvt L=2e-08 W=2.7e-08 nfin=1
M63 VDD N_M22_g N_M62_d VDD pmos_rvt L=2e-08 W=2.7e-08 nfin=1
M64 N_M22_g N_M2_g VDD VDD pmos_rvt L=2e-08 W=2.7e-08 nfin=1
M65 N_M16_d CLK VDD VDD pmos_rvt L=2e-08 W=8.1e-08 nfin=3
M66 N_M26_s N_M2_g VDD VDD pmos_rvt L=2e-08 W=5.4e-08 nfin=2
M67 VDD CLK N_M26_s VDD pmos_rvt L=2e-08 W=5.4e-08 nfin=2
M68 VDD CLK N_M26_s VDD pmos_rvt L=2e-08 W=5.4e-08 nfin=2
M69 N_M26_s N_M2_g VDD VDD pmos_rvt L=2e-08 W=5.4e-08 nfin=2
M70 GCLK N_M26_s VDD VDD pmos_rvt L=2e-08 W=5.4e-08 nfin=2
M71 GCLK N_M26_s VDD VDD pmos_rvt L=2e-08 W=5.4e-08 nfin=2
M72 N_M31_g N_M31_g VDD VDD pmos_rvt L=2e-08 W=8.1e-08 nfin=3
M73 N_M31_g N_M31_g VDD VDD pmos_rvt L=2e-08 W=8.1e-08 nfin=3
M74 N_M31_g N_M31_d VDD VDD pmos_rvt L=2e-08 W=8.1e-08 nfin=3
M75 N_M31_g N_M31_d VDD VDD pmos_rvt L=2e-08 W=8.1e-08 nfin=3
M76 N_M36_s N_M2_g VDD VDD pmos_rvt L=2e-08 W=5.4e-08 nfin=2
M77 VDD CLK N_M36_s VDD pmos_rvt L=2e-08 W=5.4e-08 nfin=2
M78 VDD CLK N_M36_s VDD pmos_rvt L=2e-08 W=5.4e-08 nfin=2
M79 N_M36_s N_M2_g VDD VDD pmos_rvt L=2e-08 W=5.4e-08 nfin=2
M80 GCLK N_M36_s VDD VDD pmos_rvt L=2e-08 W=2.7e-08 nfin=1
M81 GCLK N_M36_s VDD VDD pmos_rvt L=2e-08 W=2.7e-08 nfin=1
.ENDS

.SUBCKT ICGx4_ASAP7_75t_R CLK ENA GCLK SE VDD VSS
M0 N_M0_d ENA VSS VSS nmos_rvt L=2e-08 W=5.4e-08 nfin=2
M1 VSS SE N_M0_d VSS nmos_rvt L=2e-08 W=5.4e-08 nfin=2
M2 N_M2_d N_M0_d VSS VSS nmos_rvt L=2e-08 W=8.1e-08 nfin=3
M3 N_M3_d N_M3_g N_M2_d VSS nmos_rvt L=2e-08 W=8.1e-08 nfin=3
M4 N_M4_d CLK N_M3_d VSS nmos_rvt L=2e-08 W=2.7e-08 nfin=1
M5 VSS N_M5_g N_M4_d VSS nmos_rvt L=2e-08 W=2.7e-08 nfin=1
M6 N_M5_g N_M3_d VSS VSS nmos_rvt L=2e-08 W=2.7e-08 nfin=1
M7 VSS CLK N_M3_g VSS nmos_rvt L=2e-08 W=8.1e-08 nfin=3
M8 VSS N_M3_d N_M8_s VSS nmos_rvt L=2e-08 W=8.1e-08 nfin=3
M9 N_M8_s CLK N_M9_s VSS nmos_rvt L=2e-08 W=8.1e-08 nfin=3
M10 N_M10_d CLK N_M9_s VSS nmos_rvt L=2e-08 W=8.1e-08 nfin=3
M11 VSS N_M3_d N_M10_d VSS nmos_rvt L=2e-08 W=8.1e-08 nfin=3
M12 GCLK N_M9_s VSS VSS nmos_rvt L=2e-08 W=8.1e-08 nfin=3
M13 GCLK N_M9_s VSS VSS nmos_rvt L=2e-08 W=8.1e-08 nfin=3
M14 GCLK N_M9_s VSS VSS nmos_rvt L=2e-08 W=8.1e-08 nfin=3
M15 GCLK N_M9_s VSS VSS nmos_rvt L=2e-08 W=8.1e-08 nfin=3
M16 N_M16_d ENA N_M0_d VDD pmos_rvt L=2e-08 W=5.4e-08 nfin=2
M17 VDD SE N_M16_d VDD pmos_rvt L=2e-08 W=5.4e-08 nfin=2
M18 N_M18_d N_M0_d VDD VDD pmos_rvt L=2e-08 W=8.1e-08 nfin=3
M19 N_M3_d CLK N_M18_d VDD pmos_rvt L=2e-08 W=8.1e-08 nfin=3
M20 N_M20_d N_M3_g N_M3_d VDD pmos_rvt L=2e-08 W=2.7e-08 nfin=1
M21 VDD N_M5_g N_M20_d VDD pmos_rvt L=2e-08 W=2.7e-08 nfin=1
M22 N_M5_g N_M3_d VDD VDD pmos_rvt L=2e-08 W=2.7e-08 nfin=1
M23 VDD CLK N_M3_g VDD pmos_rvt L=2e-08 W=8.1e-08 nfin=3
M24 N_M9_s N_M3_d VDD VDD pmos_rvt L=2e-08 W=5.4e-08 nfin=2
M25 VDD CLK N_M9_s VDD pmos_rvt L=2e-08 W=5.4e-08 nfin=2
M26 VDD CLK N_M9_s VDD pmos_rvt L=2e-08 W=5.4e-08 nfin=2
M27 N_M9_s N_M3_d VDD VDD pmos_rvt L=2e-08 W=5.4e-08 nfin=2
M28 GCLK N_M9_s VDD VDD pmos_rvt L=2e-08 W=8.1e-08 nfin=3
M29 GCLK N_M9_s VDD VDD pmos_rvt L=2e-08 W=8.1e-08 nfin=3
M30 GCLK N_M9_s VDD VDD pmos_rvt L=2e-08 W=8.1e-08 nfin=3
M31 GCLK N_M9_s VDD VDD pmos_rvt L=2e-08 W=8.1e-08 nfin=3
.ENDS

.SUBCKT ICGx5_ASAP7_75t_R CLK ENA GCLK SE VDD VSS
M0 N_M0_d ENA VSS VSS nmos_rvt L=2e-08 W=5.4e-08 nfin=2
M1 VSS SE N_M0_d VSS nmos_rvt L=2e-08 W=5.4e-08 nfin=2
M2 N_M2_d N_M0_d VSS VSS nmos_rvt L=2e-08 W=8.1e-08 nfin=3
M3 N_M3_d N_M3_g N_M2_d VSS nmos_rvt L=2e-08 W=8.1e-08 nfin=3
M4 N_M4_d CLK N_M3_d VSS nmos_rvt L=2e-08 W=2.7e-08 nfin=1
M5 VSS N_M5_g N_M4_d VSS nmos_rvt L=2e-08 W=2.7e-08 nfin=1
M6 N_M5_g N_M3_d VSS VSS nmos_rvt L=2e-08 W=2.7e-08 nfin=1
M7 VSS CLK N_M3_g VSS nmos_rvt L=2e-08 W=8.1e-08 nfin=3
M8 VSS N_M3_d N_M8_s VSS nmos_rvt L=2e-08 W=8.1e-08 nfin=3
M9 N_M8_s CLK N_M9_s VSS nmos_rvt L=2e-08 W=8.1e-08 nfin=3
M10 N_M10_d CLK N_M9_s VSS nmos_rvt L=2e-08 W=8.1e-08 nfin=3
M11 VSS N_M3_d N_M10_d VSS nmos_rvt L=2e-08 W=8.1e-08 nfin=3
M12 GCLK N_M9_s VSS VSS nmos_rvt L=2e-08 W=8.1e-08 nfin=3
M13 GCLK N_M9_s VSS VSS nmos_rvt L=2e-08 W=8.1e-08 nfin=3
M14 GCLK N_M9_s VSS VSS nmos_rvt L=2e-08 W=8.1e-08 nfin=3
M15 GCLK N_M9_s VSS VSS nmos_rvt L=2e-08 W=8.1e-08 nfin=3
M16 GCLK N_M9_s VSS VSS nmos_rvt L=2e-08 W=8.1e-08 nfin=3
M17 N_M17_d ENA N_M0_d VDD pmos_rvt L=2e-08 W=5.4e-08 nfin=2
M18 VDD SE N_M17_d VDD pmos_rvt L=2e-08 W=5.4e-08 nfin=2
M19 N_M19_d N_M0_d VDD VDD pmos_rvt L=2e-08 W=8.1e-08 nfin=3
M20 N_M3_d CLK N_M19_d VDD pmos_rvt L=2e-08 W=8.1e-08 nfin=3
M21 N_M21_d N_M3_g N_M3_d VDD pmos_rvt L=2e-08 W=2.7e-08 nfin=1
M22 VDD N_M5_g N_M21_d VDD pmos_rvt L=2e-08 W=2.7e-08 nfin=1
M23 N_M5_g N_M3_d VDD VDD pmos_rvt L=2e-08 W=2.7e-08 nfin=1
M24 VDD CLK N_M3_g VDD pmos_rvt L=2e-08 W=8.1e-08 nfin=3
M25 N_M9_s N_M3_d VDD VDD pmos_rvt L=2e-08 W=5.4e-08 nfin=2
M26 VDD CLK N_M9_s VDD pmos_rvt L=2e-08 W=5.4e-08 nfin=2
M27 VDD CLK N_M9_s VDD pmos_rvt L=2e-08 W=5.4e-08 nfin=2
M28 N_M9_s N_M3_d VDD VDD pmos_rvt L=2e-08 W=5.4e-08 nfin=2
M29 GCLK N_M9_s VDD VDD pmos_rvt L=2e-08 W=8.1e-08 nfin=3
M30 GCLK N_M9_s VDD VDD pmos_rvt L=2e-08 W=8.1e-08 nfin=3
M31 GCLK N_M9_s VDD VDD pmos_rvt L=2e-08 W=8.1e-08 nfin=3
M32 GCLK N_M9_s VDD VDD pmos_rvt L=2e-08 W=8.1e-08 nfin=3
M33 GCLK N_M9_s VDD VDD pmos_rvt L=2e-08 W=8.1e-08 nfin=3
.ENDS

.SUBCKT ICGx5p33DC_ASAP7_75t_R CLK ENA GCLK SE VDD VSS
M0 GCLK N_M0_g VSS VSS nmos_rvt L=2e-08 W=5.4e-08 nfin=2
M1 GCLK N_M0_g VSS VSS nmos_rvt L=2e-08 W=5.4e-08 nfin=2
M2 VSS N_M2_g N_M2_s VSS nmos_rvt L=2e-08 W=8.1e-08 nfin=3
M3 N_M2_s CLK N_M0_g VSS nmos_rvt L=2e-08 W=8.1e-08 nfin=3
M4 N_M4_d CLK N_M0_g VSS nmos_rvt L=2e-08 W=8.1e-08 nfin=3
M5 VSS N_M2_g N_M4_d VSS nmos_rvt L=2e-08 W=8.1e-08 nfin=3
M6 N_M6_d N_M6_d VSS VSS nmos_rvt L=2e-08 W=8.1e-08 nfin=3
M7 N_M6_d N_M6_d VSS VSS nmos_rvt L=2e-08 W=8.1e-08 nfin=3
M8 N_M6_d N_M8_g VSS VSS nmos_rvt L=2e-08 W=8.1e-08 nfin=3
M9 N_M6_d N_M8_g VSS VSS nmos_rvt L=2e-08 W=8.1e-08 nfin=3
M10 GCLK N_M10_g VSS VSS nmos_rvt L=2e-08 W=5.4e-08 nfin=2
M11 GCLK N_M10_g VSS VSS nmos_rvt L=2e-08 W=5.4e-08 nfin=2
M12 VSS N_M2_g N_M12_s VSS nmos_rvt L=2e-08 W=8.1e-08 nfin=3
M13 N_M12_s CLK N_M10_g VSS nmos_rvt L=2e-08 W=8.1e-08 nfin=3
M14 N_M14_d CLK N_M10_g VSS nmos_rvt L=2e-08 W=8.1e-08 nfin=3
M15 VSS N_M2_g N_M14_d VSS nmos_rvt L=2e-08 W=8.1e-08 nfin=3
M16 N_M16_d CLK VSS VSS nmos_rvt L=2e-08 W=8.1e-08 nfin=3
M17 N_M17_d ENA VSS VSS nmos_rvt L=2e-08 W=5.4e-08 nfin=2
M18 VSS SE N_M17_d VSS nmos_rvt L=2e-08 W=5.4e-08 nfin=2
M19 N_M19_d N_M17_d VSS VSS nmos_rvt L=2e-08 W=8.1e-08 nfin=3
M20 N_M2_g N_M16_d N_M19_d VSS nmos_rvt L=2e-08 W=8.1e-08 nfin=3
M21 N_M21_d CLK N_M2_g VSS nmos_rvt L=2e-08 W=2.7e-08 nfin=1
M22 VSS N_M22_g N_M21_d VSS nmos_rvt L=2e-08 W=2.7e-08 nfin=1
M23 N_M22_g N_M2_g VSS VSS nmos_rvt L=2e-08 W=2.7e-08 nfin=1
M24 N_M16_d CLK VSS VSS nmos_rvt L=2e-08 W=8.1e-08 nfin=3
M25 VSS N_M2_g N_M25_s VSS nmos_rvt L=2e-08 W=8.1e-08 nfin=3
M26 N_M25_s CLK N_M26_s VSS nmos_rvt L=2e-08 W=8.1e-08 nfin=3
M27 N_M27_d CLK N_M26_s VSS nmos_rvt L=2e-08 W=8.1e-08 nfin=3
M28 VSS N_M2_g N_M27_d VSS nmos_rvt L=2e-08 W=8.1e-08 nfin=3
M29 GCLK N_M26_s VSS VSS nmos_rvt L=2e-08 W=5.4e-08 nfin=2
M30 GCLK N_M26_s VSS VSS nmos_rvt L=2e-08 W=5.4e-08 nfin=2
M31 N_M31_d N_M31_g VSS VSS nmos_rvt L=2e-08 W=8.1e-08 nfin=3
M32 N_M31_d N_M31_g VSS VSS nmos_rvt L=2e-08 W=8.1e-08 nfin=3
M33 N_M31_d N_M31_d VSS VSS nmos_rvt L=2e-08 W=8.1e-08 nfin=3
M34 N_M31_d N_M31_d VSS VSS nmos_rvt L=2e-08 W=8.1e-08 nfin=3
M35 VSS N_M2_g N_M35_s VSS nmos_rvt L=2e-08 W=8.1e-08 nfin=3
M36 N_M35_s CLK N_M36_s VSS nmos_rvt L=2e-08 W=8.1e-08 nfin=3
M37 N_M37_d CLK N_M36_s VSS nmos_rvt L=2e-08 W=8.1e-08 nfin=3
M38 VSS N_M2_g N_M37_d VSS nmos_rvt L=2e-08 W=8.1e-08 nfin=3
M39 GCLK N_M36_s VSS VSS nmos_rvt L=2e-08 W=5.4e-08 nfin=2
M40 GCLK N_M36_s VSS VSS nmos_rvt L=2e-08 W=5.4e-08 nfin=2
M41 GCLK N_M0_g VDD VDD pmos_rvt L=2e-08 W=5.4e-08 nfin=2
M42 GCLK N_M0_g VDD VDD pmos_rvt L=2e-08 W=5.4e-08 nfin=2
M43 N_M0_g N_M2_g VDD VDD pmos_rvt L=2e-08 W=5.4e-08 nfin=2
M44 VDD CLK N_M0_g VDD pmos_rvt L=2e-08 W=5.4e-08 nfin=2
M45 VDD CLK N_M0_g VDD pmos_rvt L=2e-08 W=5.4e-08 nfin=2
M46 N_M0_g N_M2_g VDD VDD pmos_rvt L=2e-08 W=5.4e-08 nfin=2
M47 N_M8_g N_M6_d VDD VDD pmos_rvt L=2e-08 W=8.1e-08 nfin=3
M48 N_M8_g N_M6_d VDD VDD pmos_rvt L=2e-08 W=8.1e-08 nfin=3
M49 N_M8_g N_M8_g VDD VDD pmos_rvt L=2e-08 W=8.1e-08 nfin=3
M50 N_M8_g N_M8_g VDD VDD pmos_rvt L=2e-08 W=8.1e-08 nfin=3
M51 GCLK N_M10_g VDD VDD pmos_rvt L=2e-08 W=5.4e-08 nfin=2
M52 GCLK N_M10_g VDD VDD pmos_rvt L=2e-08 W=5.4e-08 nfin=2
M53 N_M10_g N_M2_g VDD VDD pmos_rvt L=2e-08 W=5.4e-08 nfin=2
M54 VDD CLK N_M10_g VDD pmos_rvt L=2e-08 W=5.4e-08 nfin=2
M55 VDD CLK N_M10_g VDD pmos_rvt L=2e-08 W=5.4e-08 nfin=2
M56 N_M10_g N_M2_g VDD VDD pmos_rvt L=2e-08 W=5.4e-08 nfin=2
M57 N_M16_d CLK VDD VDD pmos_rvt L=2e-08 W=8.1e-08 nfin=3
M58 N_M58_d ENA N_M17_d VDD pmos_rvt L=2e-08 W=5.4e-08 nfin=2
M59 VDD SE N_M58_d VDD pmos_rvt L=2e-08 W=5.4e-08 nfin=2
M60 N_M60_d N_M17_d VDD VDD pmos_rvt L=2e-08 W=8.1e-08 nfin=3
M61 N_M2_g CLK N_M60_d VDD pmos_rvt L=2e-08 W=8.1e-08 nfin=3
M62 N_M62_d N_M16_d N_M2_g VDD pmos_rvt L=2e-08 W=2.7e-08 nfin=1
M63 VDD N_M22_g N_M62_d VDD pmos_rvt L=2e-08 W=2.7e-08 nfin=1
M64 N_M22_g N_M2_g VDD VDD pmos_rvt L=2e-08 W=2.7e-08 nfin=1
M65 N_M16_d CLK VDD VDD pmos_rvt L=2e-08 W=8.1e-08 nfin=3
M66 N_M26_s N_M2_g VDD VDD pmos_rvt L=2e-08 W=5.4e-08 nfin=2
M67 VDD CLK N_M26_s VDD pmos_rvt L=2e-08 W=5.4e-08 nfin=2
M68 VDD CLK N_M26_s VDD pmos_rvt L=2e-08 W=5.4e-08 nfin=2
M69 N_M26_s N_M2_g VDD VDD pmos_rvt L=2e-08 W=5.4e-08 nfin=2
M70 GCLK N_M26_s VDD VDD pmos_rvt L=2e-08 W=5.4e-08 nfin=2
M71 GCLK N_M26_s VDD VDD pmos_rvt L=2e-08 W=5.4e-08 nfin=2
M72 N_M31_g N_M31_g VDD VDD pmos_rvt L=2e-08 W=8.1e-08 nfin=3
M73 N_M31_g N_M31_g VDD VDD pmos_rvt L=2e-08 W=8.1e-08 nfin=3
M74 N_M31_g N_M31_d VDD VDD pmos_rvt L=2e-08 W=8.1e-08 nfin=3
M75 N_M31_g N_M31_d VDD VDD pmos_rvt L=2e-08 W=8.1e-08 nfin=3
M76 N_M36_s N_M2_g VDD VDD pmos_rvt L=2e-08 W=5.4e-08 nfin=2
M77 VDD CLK N_M36_s VDD pmos_rvt L=2e-08 W=5.4e-08 nfin=2
M78 VDD CLK N_M36_s VDD pmos_rvt L=2e-08 W=5.4e-08 nfin=2
M79 N_M36_s N_M2_g VDD VDD pmos_rvt L=2e-08 W=5.4e-08 nfin=2
M80 GCLK N_M36_s VDD VDD pmos_rvt L=2e-08 W=5.4e-08 nfin=2
M81 GCLK N_M36_s VDD VDD pmos_rvt L=2e-08 W=5.4e-08 nfin=2
.ENDS

.SUBCKT ICGx6p67DC_ASAP7_75t_R CLK ENA GCLK SE VDD VSS
M0 GCLK N_M0_g VSS VSS nmos_rvt L=2e-08 W=5.4e-08 nfin=2
M1 GCLK N_M0_g VSS VSS nmos_rvt L=2e-08 W=5.4e-08 nfin=2
M2 VSS N_M2_g N_M2_s VSS nmos_rvt L=2e-08 W=8.1e-08 nfin=3
M3 N_M2_s CLK N_M0_g VSS nmos_rvt L=2e-08 W=8.1e-08 nfin=3
M4 N_M4_d CLK N_M0_g VSS nmos_rvt L=2e-08 W=8.1e-08 nfin=3
M5 VSS N_M2_g N_M4_d VSS nmos_rvt L=2e-08 W=8.1e-08 nfin=3
M6 N_M6_d N_M6_d VSS VSS nmos_rvt L=2e-08 W=8.1e-08 nfin=3
M7 N_M6_d N_M6_d VSS VSS nmos_rvt L=2e-08 W=8.1e-08 nfin=3
M8 N_M6_d N_M8_g VSS VSS nmos_rvt L=2e-08 W=8.1e-08 nfin=3
M9 N_M6_d N_M8_g VSS VSS nmos_rvt L=2e-08 W=8.1e-08 nfin=3
M10 GCLK N_M10_g VSS VSS nmos_rvt L=2e-08 W=8.1e-08 nfin=3
M11 GCLK N_M10_g VSS VSS nmos_rvt L=2e-08 W=8.1e-08 nfin=3
M12 VSS N_M2_g N_M12_s VSS nmos_rvt L=2e-08 W=8.1e-08 nfin=3
M13 N_M12_s CLK N_M10_g VSS nmos_rvt L=2e-08 W=8.1e-08 nfin=3
M14 N_M14_d CLK N_M10_g VSS nmos_rvt L=2e-08 W=8.1e-08 nfin=3
M15 VSS N_M2_g N_M14_d VSS nmos_rvt L=2e-08 W=8.1e-08 nfin=3
M16 N_M16_d CLK VSS VSS nmos_rvt L=2e-08 W=8.1e-08 nfin=3
M17 N_M17_d ENA VSS VSS nmos_rvt L=2e-08 W=5.4e-08 nfin=2
M18 VSS SE N_M17_d VSS nmos_rvt L=2e-08 W=5.4e-08 nfin=2
M19 N_M19_d N_M17_d VSS VSS nmos_rvt L=2e-08 W=8.1e-08 nfin=3
M20 N_M2_g N_M16_d N_M19_d VSS nmos_rvt L=2e-08 W=8.1e-08 nfin=3
M21 N_M21_d CLK N_M2_g VSS nmos_rvt L=2e-08 W=2.7e-08 nfin=1
M22 VSS N_M22_g N_M21_d VSS nmos_rvt L=2e-08 W=2.7e-08 nfin=1
M23 N_M22_g N_M2_g VSS VSS nmos_rvt L=2e-08 W=2.7e-08 nfin=1
M24 N_M16_d CLK VSS VSS nmos_rvt L=2e-08 W=8.1e-08 nfin=3
M25 VSS N_M2_g N_M25_s VSS nmos_rvt L=2e-08 W=8.1e-08 nfin=3
M26 N_M25_s CLK N_M26_s VSS nmos_rvt L=2e-08 W=8.1e-08 nfin=3
M27 N_M27_d CLK N_M26_s VSS nmos_rvt L=2e-08 W=8.1e-08 nfin=3
M28 VSS N_M2_g N_M27_d VSS nmos_rvt L=2e-08 W=8.1e-08 nfin=3
M29 GCLK N_M26_s VSS VSS nmos_rvt L=2e-08 W=8.1e-08 nfin=3
M30 GCLK N_M26_s VSS VSS nmos_rvt L=2e-08 W=8.1e-08 nfin=3
M31 N_M31_d N_M31_g VSS VSS nmos_rvt L=2e-08 W=8.1e-08 nfin=3
M32 N_M31_d N_M31_g VSS VSS nmos_rvt L=2e-08 W=8.1e-08 nfin=3
M33 N_M31_d N_M31_d VSS VSS nmos_rvt L=2e-08 W=8.1e-08 nfin=3
M34 N_M31_d N_M31_d VSS VSS nmos_rvt L=2e-08 W=8.1e-08 nfin=3
M35 VSS N_M2_g N_M35_s VSS nmos_rvt L=2e-08 W=8.1e-08 nfin=3
M36 N_M35_s CLK N_M36_s VSS nmos_rvt L=2e-08 W=8.1e-08 nfin=3
M37 N_M37_d CLK N_M36_s VSS nmos_rvt L=2e-08 W=8.1e-08 nfin=3
M38 VSS N_M2_g N_M37_d VSS nmos_rvt L=2e-08 W=8.1e-08 nfin=3
M39 GCLK N_M36_s VSS VSS nmos_rvt L=2e-08 W=5.4e-08 nfin=2
M40 GCLK N_M36_s VSS VSS nmos_rvt L=2e-08 W=5.4e-08 nfin=2
M41 GCLK N_M0_g VDD VDD pmos_rvt L=2e-08 W=5.4e-08 nfin=2
M42 GCLK N_M0_g VDD VDD pmos_rvt L=2e-08 W=5.4e-08 nfin=2
M43 N_M0_g N_M2_g VDD VDD pmos_rvt L=2e-08 W=5.4e-08 nfin=2
M44 VDD CLK N_M0_g VDD pmos_rvt L=2e-08 W=5.4e-08 nfin=2
M45 VDD CLK N_M0_g VDD pmos_rvt L=2e-08 W=5.4e-08 nfin=2
M46 N_M0_g N_M2_g VDD VDD pmos_rvt L=2e-08 W=5.4e-08 nfin=2
M47 N_M8_g N_M6_d VDD VDD pmos_rvt L=2e-08 W=8.1e-08 nfin=3
M48 N_M8_g N_M6_d VDD VDD pmos_rvt L=2e-08 W=8.1e-08 nfin=3
M49 N_M8_g N_M8_g VDD VDD pmos_rvt L=2e-08 W=8.1e-08 nfin=3
M50 N_M8_g N_M8_g VDD VDD pmos_rvt L=2e-08 W=8.1e-08 nfin=3
M51 GCLK N_M10_g VDD VDD pmos_rvt L=2e-08 W=8.1e-08 nfin=3
M52 GCLK N_M10_g VDD VDD pmos_rvt L=2e-08 W=8.1e-08 nfin=3
M53 N_M10_g N_M2_g VDD VDD pmos_rvt L=2e-08 W=5.4e-08 nfin=2
M54 VDD CLK N_M10_g VDD pmos_rvt L=2e-08 W=5.4e-08 nfin=2
M55 VDD CLK N_M10_g VDD pmos_rvt L=2e-08 W=5.4e-08 nfin=2
M56 N_M10_g N_M2_g VDD VDD pmos_rvt L=2e-08 W=5.4e-08 nfin=2
M57 N_M16_d CLK VDD VDD pmos_rvt L=2e-08 W=8.1e-08 nfin=3
M58 N_M58_d ENA N_M17_d VDD pmos_rvt L=2e-08 W=5.4e-08 nfin=2
M59 VDD SE N_M58_d VDD pmos_rvt L=2e-08 W=5.4e-08 nfin=2
M60 N_M60_d N_M17_d VDD VDD pmos_rvt L=2e-08 W=8.1e-08 nfin=3
M61 N_M2_g CLK N_M60_d VDD pmos_rvt L=2e-08 W=8.1e-08 nfin=3
M62 N_M62_d N_M16_d N_M2_g VDD pmos_rvt L=2e-08 W=2.7e-08 nfin=1
M63 VDD N_M22_g N_M62_d VDD pmos_rvt L=2e-08 W=2.7e-08 nfin=1
M64 N_M22_g N_M2_g VDD VDD pmos_rvt L=2e-08 W=2.7e-08 nfin=1
M65 N_M16_d CLK VDD VDD pmos_rvt L=2e-08 W=8.1e-08 nfin=3
M66 N_M26_s N_M2_g VDD VDD pmos_rvt L=2e-08 W=5.4e-08 nfin=2
M67 VDD CLK N_M26_s VDD pmos_rvt L=2e-08 W=5.4e-08 nfin=2
M68 VDD CLK N_M26_s VDD pmos_rvt L=2e-08 W=5.4e-08 nfin=2
M69 N_M26_s N_M2_g VDD VDD pmos_rvt L=2e-08 W=5.4e-08 nfin=2
M70 GCLK N_M26_s VDD VDD pmos_rvt L=2e-08 W=8.1e-08 nfin=3
M71 GCLK N_M26_s VDD VDD pmos_rvt L=2e-08 W=8.1e-08 nfin=3
M72 N_M31_g N_M31_g VDD VDD pmos_rvt L=2e-08 W=8.1e-08 nfin=3
M73 N_M31_g N_M31_g VDD VDD pmos_rvt L=2e-08 W=8.1e-08 nfin=3
M74 N_M31_g N_M31_d VDD VDD pmos_rvt L=2e-08 W=8.1e-08 nfin=3
M75 N_M31_g N_M31_d VDD VDD pmos_rvt L=2e-08 W=8.1e-08 nfin=3
M76 N_M36_s N_M2_g VDD VDD pmos_rvt L=2e-08 W=5.4e-08 nfin=2
M77 VDD CLK N_M36_s VDD pmos_rvt L=2e-08 W=5.4e-08 nfin=2
M78 VDD CLK N_M36_s VDD pmos_rvt L=2e-08 W=5.4e-08 nfin=2
M79 N_M36_s N_M2_g VDD VDD pmos_rvt L=2e-08 W=5.4e-08 nfin=2
M80 GCLK N_M36_s VDD VDD pmos_rvt L=2e-08 W=5.4e-08 nfin=2
M81 GCLK N_M36_s VDD VDD pmos_rvt L=2e-08 W=5.4e-08 nfin=2
.ENDS

.SUBCKT ICGx8DC_ASAP7_75t_R CLK ENA GCLK SE VDD VSS
M0 GCLK N_M0_g VSS VSS nmos_rvt L=2e-08 W=8.1e-08 nfin=3
M1 GCLK N_M0_g VSS VSS nmos_rvt L=2e-08 W=8.1e-08 nfin=3
M2 VSS N_M2_g N_M2_s VSS nmos_rvt L=2e-08 W=8.1e-08 nfin=3
M3 N_M2_s CLK N_M0_g VSS nmos_rvt L=2e-08 W=8.1e-08 nfin=3
M4 N_M4_d CLK N_M0_g VSS nmos_rvt L=2e-08 W=8.1e-08 nfin=3
M5 VSS N_M2_g N_M4_d VSS nmos_rvt L=2e-08 W=8.1e-08 nfin=3
M6 N_M6_d N_M6_d VSS VSS nmos_rvt L=2e-08 W=8.1e-08 nfin=3
M7 N_M6_d N_M6_d VSS VSS nmos_rvt L=2e-08 W=8.1e-08 nfin=3
M8 N_M6_d N_M8_g VSS VSS nmos_rvt L=2e-08 W=8.1e-08 nfin=3
M9 N_M6_d N_M8_g VSS VSS nmos_rvt L=2e-08 W=8.1e-08 nfin=3
M10 GCLK N_M10_g VSS VSS nmos_rvt L=2e-08 W=8.1e-08 nfin=3
M11 GCLK N_M10_g VSS VSS nmos_rvt L=2e-08 W=8.1e-08 nfin=3
M12 VSS N_M2_g N_M12_s VSS nmos_rvt L=2e-08 W=8.1e-08 nfin=3
M13 N_M12_s CLK N_M10_g VSS nmos_rvt L=2e-08 W=8.1e-08 nfin=3
M14 N_M14_d CLK N_M10_g VSS nmos_rvt L=2e-08 W=8.1e-08 nfin=3
M15 VSS N_M2_g N_M14_d VSS nmos_rvt L=2e-08 W=8.1e-08 nfin=3
M16 N_M16_d CLK VSS VSS nmos_rvt L=2e-08 W=8.1e-08 nfin=3
M17 N_M17_d ENA VSS VSS nmos_rvt L=2e-08 W=5.4e-08 nfin=2
M18 VSS SE N_M17_d VSS nmos_rvt L=2e-08 W=5.4e-08 nfin=2
M19 N_M19_d N_M17_d VSS VSS nmos_rvt L=2e-08 W=8.1e-08 nfin=3
M20 N_M2_g N_M16_d N_M19_d VSS nmos_rvt L=2e-08 W=8.1e-08 nfin=3
M21 N_M21_d CLK N_M2_g VSS nmos_rvt L=2e-08 W=2.7e-08 nfin=1
M22 VSS N_M22_g N_M21_d VSS nmos_rvt L=2e-08 W=2.7e-08 nfin=1
M23 N_M22_g N_M2_g VSS VSS nmos_rvt L=2e-08 W=2.7e-08 nfin=1
M24 N_M16_d CLK VSS VSS nmos_rvt L=2e-08 W=8.1e-08 nfin=3
M25 VSS N_M2_g N_M25_s VSS nmos_rvt L=2e-08 W=8.1e-08 nfin=3
M26 N_M25_s CLK N_M26_s VSS nmos_rvt L=2e-08 W=8.1e-08 nfin=3
M27 N_M27_d CLK N_M26_s VSS nmos_rvt L=2e-08 W=8.1e-08 nfin=3
M28 VSS N_M2_g N_M27_d VSS nmos_rvt L=2e-08 W=8.1e-08 nfin=3
M29 GCLK N_M26_s VSS VSS nmos_rvt L=2e-08 W=8.1e-08 nfin=3
M30 GCLK N_M26_s VSS VSS nmos_rvt L=2e-08 W=8.1e-08 nfin=3
M31 N_M31_d N_M31_g VSS VSS nmos_rvt L=2e-08 W=8.1e-08 nfin=3
M32 N_M31_d N_M31_g VSS VSS nmos_rvt L=2e-08 W=8.1e-08 nfin=3
M33 N_M31_d N_M31_d VSS VSS nmos_rvt L=2e-08 W=8.1e-08 nfin=3
M34 N_M31_d N_M31_d VSS VSS nmos_rvt L=2e-08 W=8.1e-08 nfin=3
M35 VSS N_M2_g N_M35_s VSS nmos_rvt L=2e-08 W=8.1e-08 nfin=3
M36 N_M35_s CLK N_M36_s VSS nmos_rvt L=2e-08 W=8.1e-08 nfin=3
M37 N_M37_d CLK N_M36_s VSS nmos_rvt L=2e-08 W=8.1e-08 nfin=3
M38 VSS N_M2_g N_M37_d VSS nmos_rvt L=2e-08 W=8.1e-08 nfin=3
M39 GCLK N_M36_s VSS VSS nmos_rvt L=2e-08 W=8.1e-08 nfin=3
M40 GCLK N_M36_s VSS VSS nmos_rvt L=2e-08 W=8.1e-08 nfin=3
M41 GCLK N_M0_g VDD VDD pmos_rvt L=2e-08 W=8.1e-08 nfin=3
M42 GCLK N_M0_g VDD VDD pmos_rvt L=2e-08 W=8.1e-08 nfin=3
M43 N_M0_g N_M2_g VDD VDD pmos_rvt L=2e-08 W=5.4e-08 nfin=2
M44 VDD CLK N_M0_g VDD pmos_rvt L=2e-08 W=5.4e-08 nfin=2
M45 VDD CLK N_M0_g VDD pmos_rvt L=2e-08 W=5.4e-08 nfin=2
M46 N_M0_g N_M2_g VDD VDD pmos_rvt L=2e-08 W=5.4e-08 nfin=2
M47 N_M8_g N_M6_d VDD VDD pmos_rvt L=2e-08 W=8.1e-08 nfin=3
M48 N_M8_g N_M6_d VDD VDD pmos_rvt L=2e-08 W=8.1e-08 nfin=3
M49 N_M8_g N_M8_g VDD VDD pmos_rvt L=2e-08 W=8.1e-08 nfin=3
M50 N_M8_g N_M8_g VDD VDD pmos_rvt L=2e-08 W=8.1e-08 nfin=3
M51 GCLK N_M10_g VDD VDD pmos_rvt L=2e-08 W=8.1e-08 nfin=3
M52 GCLK N_M10_g VDD VDD pmos_rvt L=2e-08 W=8.1e-08 nfin=3
M53 N_M10_g N_M2_g VDD VDD pmos_rvt L=2e-08 W=5.4e-08 nfin=2
M54 VDD CLK N_M10_g VDD pmos_rvt L=2e-08 W=5.4e-08 nfin=2
M55 VDD CLK N_M10_g VDD pmos_rvt L=2e-08 W=5.4e-08 nfin=2
M56 N_M10_g N_M2_g VDD VDD pmos_rvt L=2e-08 W=5.4e-08 nfin=2
M57 N_M16_d CLK VDD VDD pmos_rvt L=2e-08 W=8.1e-08 nfin=3
M58 N_M58_d ENA N_M17_d VDD pmos_rvt L=2e-08 W=5.4e-08 nfin=2
M59 VDD SE N_M58_d VDD pmos_rvt L=2e-08 W=5.4e-08 nfin=2
M60 N_M60_d N_M17_d VDD VDD pmos_rvt L=2e-08 W=8.1e-08 nfin=3
M61 N_M2_g CLK N_M60_d VDD pmos_rvt L=2e-08 W=8.1e-08 nfin=3
M62 N_M62_d N_M16_d N_M2_g VDD pmos_rvt L=2e-08 W=2.7e-08 nfin=1
M63 VDD N_M22_g N_M62_d VDD pmos_rvt L=2e-08 W=2.7e-08 nfin=1
M64 N_M22_g N_M2_g VDD VDD pmos_rvt L=2e-08 W=2.7e-08 nfin=1
M65 N_M16_d CLK VDD VDD pmos_rvt L=2e-08 W=8.1e-08 nfin=3
M66 N_M26_s N_M2_g VDD VDD pmos_rvt L=2e-08 W=5.4e-08 nfin=2
M67 VDD CLK N_M26_s VDD pmos_rvt L=2e-08 W=5.4e-08 nfin=2
M68 VDD CLK N_M26_s VDD pmos_rvt L=2e-08 W=5.4e-08 nfin=2
M69 N_M26_s N_M2_g VDD VDD pmos_rvt L=2e-08 W=5.4e-08 nfin=2
M70 GCLK N_M26_s VDD VDD pmos_rvt L=2e-08 W=8.1e-08 nfin=3
M71 GCLK N_M26_s VDD VDD pmos_rvt L=2e-08 W=8.1e-08 nfin=3
M72 N_M31_g N_M31_g VDD VDD pmos_rvt L=2e-08 W=8.1e-08 nfin=3
M73 N_M31_g N_M31_g VDD VDD pmos_rvt L=2e-08 W=8.1e-08 nfin=3
M74 N_M31_g N_M31_d VDD VDD pmos_rvt L=2e-08 W=8.1e-08 nfin=3
M75 N_M31_g N_M31_d VDD VDD pmos_rvt L=2e-08 W=8.1e-08 nfin=3
M76 N_M36_s N_M2_g VDD VDD pmos_rvt L=2e-08 W=5.4e-08 nfin=2
M77 VDD CLK N_M36_s VDD pmos_rvt L=2e-08 W=5.4e-08 nfin=2
M78 VDD CLK N_M36_s VDD pmos_rvt L=2e-08 W=5.4e-08 nfin=2
M79 N_M36_s N_M2_g VDD VDD pmos_rvt L=2e-08 W=5.4e-08 nfin=2
M80 GCLK N_M36_s VDD VDD pmos_rvt L=2e-08 W=8.1e-08 nfin=3
M81 GCLK N_M36_s VDD VDD pmos_rvt L=2e-08 W=8.1e-08 nfin=3
.ENDS

.SUBCKT INVx11_ASAP7_75t_R A VDD VSS Y
M0 Y A VSS VSS nmos_rvt L=2e-08 W=8.1e-08 nfin=3
M1 Y A VSS VSS nmos_rvt L=2e-08 W=8.1e-08 nfin=3
M2 Y A VSS VSS nmos_rvt L=2e-08 W=8.1e-08 nfin=3
M3 Y A VSS VSS nmos_rvt L=2e-08 W=8.1e-08 nfin=3
M4 Y A VSS VSS nmos_rvt L=2e-08 W=8.1e-08 nfin=3
M5 Y A VSS VSS nmos_rvt L=2e-08 W=8.1e-08 nfin=3
M6 Y A VSS VSS nmos_rvt L=2e-08 W=8.1e-08 nfin=3
M7 Y A VSS VSS nmos_rvt L=2e-08 W=8.1e-08 nfin=3
M8 Y A VSS VSS nmos_rvt L=2e-08 W=8.1e-08 nfin=3
M9 Y A VSS VSS nmos_rvt L=2e-08 W=8.1e-08 nfin=3
M10 Y A VSS VSS nmos_rvt L=2e-08 W=8.1e-08 nfin=3
M11 Y A VDD VDD pmos_rvt L=2e-08 W=8.1e-08 nfin=3
M12 Y A VDD VDD pmos_rvt L=2e-08 W=8.1e-08 nfin=3
M13 Y A VDD VDD pmos_rvt L=2e-08 W=8.1e-08 nfin=3
M14 Y A VDD VDD pmos_rvt L=2e-08 W=8.1e-08 nfin=3
M15 Y A VDD VDD pmos_rvt L=2e-08 W=8.1e-08 nfin=3
M16 Y A VDD VDD pmos_rvt L=2e-08 W=8.1e-08 nfin=3
M17 Y A VDD VDD pmos_rvt L=2e-08 W=8.1e-08 nfin=3
M18 Y A VDD VDD pmos_rvt L=2e-08 W=8.1e-08 nfin=3
M19 Y A VDD VDD pmos_rvt L=2e-08 W=8.1e-08 nfin=3
M20 Y A VDD VDD pmos_rvt L=2e-08 W=8.1e-08 nfin=3
M21 Y A VDD VDD pmos_rvt L=2e-08 W=8.1e-08 nfin=3
.ENDS

.SUBCKT INVx13_ASAP7_75t_R A VDD VSS Y
M0 Y A VSS VSS nmos_rvt L=2e-08 W=8.1e-08 nfin=3
M1 Y A VSS VSS nmos_rvt L=2e-08 W=8.1e-08 nfin=3
M2 Y A VSS VSS nmos_rvt L=2e-08 W=8.1e-08 nfin=3
M3 Y A VSS VSS nmos_rvt L=2e-08 W=8.1e-08 nfin=3
M4 Y A VSS VSS nmos_rvt L=2e-08 W=8.1e-08 nfin=3
M5 Y A VSS VSS nmos_rvt L=2e-08 W=8.1e-08 nfin=3
M6 Y A VSS VSS nmos_rvt L=2e-08 W=8.1e-08 nfin=3
M7 Y A VSS VSS nmos_rvt L=2e-08 W=8.1e-08 nfin=3
M8 Y A VSS VSS nmos_rvt L=2e-08 W=8.1e-08 nfin=3
M9 Y A VSS VSS nmos_rvt L=2e-08 W=8.1e-08 nfin=3
M10 Y A VSS VSS nmos_rvt L=2e-08 W=8.1e-08 nfin=3
M11 Y A VSS VSS nmos_rvt L=2e-08 W=8.1e-08 nfin=3
M12 Y A VSS VSS nmos_rvt L=2e-08 W=8.1e-08 nfin=3
M13 Y A VDD VDD pmos_rvt L=2e-08 W=8.1e-08 nfin=3
M14 Y A VDD VDD pmos_rvt L=2e-08 W=8.1e-08 nfin=3
M15 Y A VDD VDD pmos_rvt L=2e-08 W=8.1e-08 nfin=3
M16 Y A VDD VDD pmos_rvt L=2e-08 W=8.1e-08 nfin=3
M17 Y A VDD VDD pmos_rvt L=2e-08 W=8.1e-08 nfin=3
M18 Y A VDD VDD pmos_rvt L=2e-08 W=8.1e-08 nfin=3
M19 Y A VDD VDD pmos_rvt L=2e-08 W=8.1e-08 nfin=3
M20 Y A VDD VDD pmos_rvt L=2e-08 W=8.1e-08 nfin=3
M21 Y A VDD VDD pmos_rvt L=2e-08 W=8.1e-08 nfin=3
M22 Y A VDD VDD pmos_rvt L=2e-08 W=8.1e-08 nfin=3
M23 Y A VDD VDD pmos_rvt L=2e-08 W=8.1e-08 nfin=3
M24 Y A VDD VDD pmos_rvt L=2e-08 W=8.1e-08 nfin=3
M25 Y A VDD VDD pmos_rvt L=2e-08 W=8.1e-08 nfin=3
.ENDS

.SUBCKT INVx1_ASAP7_75t_R A VDD VSS Y
M0 Y A VSS VSS nmos_rvt L=2e-08 W=8.1e-08 nfin=3
M1 Y A VDD VDD pmos_rvt L=2e-08 W=8.1e-08 nfin=3
.ENDS

.SUBCKT INVx2_ASAP7_75t_R A VDD VSS Y
M0 Y A VSS VSS nmos_rvt L=2e-08 W=8.1e-08 nfin=3
M1 Y A VSS VSS nmos_rvt L=2e-08 W=8.1e-08 nfin=3
M2 Y A VDD VDD pmos_rvt L=2e-08 W=8.1e-08 nfin=3
M3 Y A VDD VDD pmos_rvt L=2e-08 W=8.1e-08 nfin=3
.ENDS

.SUBCKT INVx3_ASAP7_75t_R A VDD VSS Y
M0 Y A VSS VSS nmos_rvt L=2e-08 W=8.1e-08 nfin=3
M1 Y A VSS VSS nmos_rvt L=2e-08 W=8.1e-08 nfin=3
M2 Y A VSS VSS nmos_rvt L=2e-08 W=8.1e-08 nfin=3
M3 Y A VDD VDD pmos_rvt L=2e-08 W=8.1e-08 nfin=3
M4 Y A VDD VDD pmos_rvt L=2e-08 W=8.1e-08 nfin=3
M5 Y A VDD VDD pmos_rvt L=2e-08 W=8.1e-08 nfin=3
.ENDS

.SUBCKT INVx4_ASAP7_75t_R A VDD VSS Y
M0 Y A VSS VSS nmos_rvt L=2e-08 W=8.1e-08 nfin=3
M1 Y A VSS VSS nmos_rvt L=2e-08 W=8.1e-08 nfin=3
M2 Y A VSS VSS nmos_rvt L=2e-08 W=8.1e-08 nfin=3
M3 Y A VSS VSS nmos_rvt L=2e-08 W=8.1e-08 nfin=3
M4 Y A VDD VDD pmos_rvt L=2e-08 W=8.1e-08 nfin=3
M5 Y A VDD VDD pmos_rvt L=2e-08 W=8.1e-08 nfin=3
M6 Y A VDD VDD pmos_rvt L=2e-08 W=8.1e-08 nfin=3
M7 Y A VDD VDD pmos_rvt L=2e-08 W=8.1e-08 nfin=3
.ENDS

.SUBCKT INVx5_ASAP7_75t_R A VDD VSS Y
M0 Y A VSS VSS nmos_rvt L=2e-08 W=8.1e-08 nfin=3
M1 Y A VSS VSS nmos_rvt L=2e-08 W=8.1e-08 nfin=3
M2 Y A VSS VSS nmos_rvt L=2e-08 W=8.1e-08 nfin=3
M3 Y A VSS VSS nmos_rvt L=2e-08 W=8.1e-08 nfin=3
M4 Y A VSS VSS nmos_rvt L=2e-08 W=8.1e-08 nfin=3
M5 Y A VDD VDD pmos_rvt L=2e-08 W=8.1e-08 nfin=3
M6 Y A VDD VDD pmos_rvt L=2e-08 W=8.1e-08 nfin=3
M7 Y A VDD VDD pmos_rvt L=2e-08 W=8.1e-08 nfin=3
M8 Y A VDD VDD pmos_rvt L=2e-08 W=8.1e-08 nfin=3
M9 Y A VDD VDD pmos_rvt L=2e-08 W=8.1e-08 nfin=3
.ENDS

.SUBCKT INVx6_ASAP7_75t_R A VDD VSS Y
M0 Y A VSS VSS nmos_rvt L=2e-08 W=8.1e-08 nfin=3
M1 Y A VSS VSS nmos_rvt L=2e-08 W=8.1e-08 nfin=3
M2 Y A VSS VSS nmos_rvt L=2e-08 W=8.1e-08 nfin=3
M3 Y A VSS VSS nmos_rvt L=2e-08 W=8.1e-08 nfin=3
M4 Y A VSS VSS nmos_rvt L=2e-08 W=8.1e-08 nfin=3
M5 Y A VSS VSS nmos_rvt L=2e-08 W=8.1e-08 nfin=3
M6 Y A VDD VDD pmos_rvt L=2e-08 W=8.1e-08 nfin=3
M7 Y A VDD VDD pmos_rvt L=2e-08 W=8.1e-08 nfin=3
M8 Y A VDD VDD pmos_rvt L=2e-08 W=8.1e-08 nfin=3
M9 Y A VDD VDD pmos_rvt L=2e-08 W=8.1e-08 nfin=3
M10 Y A VDD VDD pmos_rvt L=2e-08 W=8.1e-08 nfin=3
M11 Y A VDD VDD pmos_rvt L=2e-08 W=8.1e-08 nfin=3
.ENDS

.SUBCKT INVx8_ASAP7_75t_R A VDD VSS Y
M0 Y A VSS VSS nmos_rvt L=2e-08 W=8.1e-08 nfin=3
M1 Y A VSS VSS nmos_rvt L=2e-08 W=8.1e-08 nfin=3
M2 Y A VSS VSS nmos_rvt L=2e-08 W=8.1e-08 nfin=3
M3 Y A VSS VSS nmos_rvt L=2e-08 W=8.1e-08 nfin=3
M4 Y A VSS VSS nmos_rvt L=2e-08 W=8.1e-08 nfin=3
M5 Y A VSS VSS nmos_rvt L=2e-08 W=8.1e-08 nfin=3
M6 Y A VSS VSS nmos_rvt L=2e-08 W=8.1e-08 nfin=3
M7 Y A VSS VSS nmos_rvt L=2e-08 W=8.1e-08 nfin=3
M8 Y A VDD VDD pmos_rvt L=2e-08 W=8.1e-08 nfin=3
M9 Y A VDD VDD pmos_rvt L=2e-08 W=8.1e-08 nfin=3
M10 Y A VDD VDD pmos_rvt L=2e-08 W=8.1e-08 nfin=3
M11 Y A VDD VDD pmos_rvt L=2e-08 W=8.1e-08 nfin=3
M12 Y A VDD VDD pmos_rvt L=2e-08 W=8.1e-08 nfin=3
M13 Y A VDD VDD pmos_rvt L=2e-08 W=8.1e-08 nfin=3
M14 Y A VDD VDD pmos_rvt L=2e-08 W=8.1e-08 nfin=3
M15 Y A VDD VDD pmos_rvt L=2e-08 W=8.1e-08 nfin=3
.ENDS

.SUBCKT INVxp33_ASAP7_75t_R A VDD VSS Y
M0 Y A VSS VSS nmos_rvt L=2e-08 W=2.7e-08 nfin=1
M1 Y A VDD VDD pmos_rvt L=2e-08 W=2.7e-08 nfin=1
.ENDS

.SUBCKT INVxp67_ASAP7_75t_R A VDD VSS Y
M0 Y A VSS VSS nmos_rvt L=2e-08 W=5.4e-08 nfin=2
M1 Y A VDD VDD pmos_rvt L=2e-08 W=5.4e-08 nfin=2
.ENDS

.SUBCKT MAJIxp5_ASAP7_75t_R A B C VDD VSS Y
M0 N_M0_d B VSS VSS nmos_rvt L=2e-08 W=8.1e-08 nfin=3
M1 VSS C N_M0_d VSS nmos_rvt L=2e-08 W=8.1e-08 nfin=3
M2 N_M2_d C VSS VSS nmos_rvt L=2e-08 W=8.1e-08 nfin=3
M3 Y B N_M2_d VSS nmos_rvt L=2e-08 W=8.1e-08 nfin=3
M4 N_M0_d A Y VSS nmos_rvt L=2e-08 W=8.1e-08 nfin=3
M5 N_M5_d B VDD VDD pmos_rvt L=2e-08 W=8.1e-08 nfin=3
M6 VDD C N_M5_d VDD pmos_rvt L=2e-08 W=8.1e-08 nfin=3
M7 N_M7_d C VDD VDD pmos_rvt L=2e-08 W=8.1e-08 nfin=3
M8 Y B N_M7_d VDD pmos_rvt L=2e-08 W=8.1e-08 nfin=3
M9 N_M5_d A Y VDD pmos_rvt L=2e-08 W=8.1e-08 nfin=3
.ENDS

.SUBCKT MAJx2_ASAP7_75t_R A B C VDD VSS Y
M0 N_M0_d A N_M0_s VSS nmos_rvt L=2e-08 W=8.1e-08 nfin=3
M1 N_M1_d B N_M0_d VSS nmos_rvt L=2e-08 W=8.1e-08 nfin=3
M2 VSS C N_M1_d VSS nmos_rvt L=2e-08 W=8.1e-08 nfin=3
M3 N_M0_s C VSS VSS nmos_rvt L=2e-08 W=8.1e-08 nfin=3
M4 VSS B N_M0_s VSS nmos_rvt L=2e-08 W=8.1e-08 nfin=3
M5 Y N_M0_d VSS VSS nmos_rvt L=2e-08 W=8.1e-08 nfin=3
M6 Y N_M0_d VSS VSS nmos_rvt L=2e-08 W=8.1e-08 nfin=3
M7 N_M0_d A N_M7_s VDD pmos_rvt L=2e-08 W=8.1e-08 nfin=3
M8 N_M8_d B N_M0_d VDD pmos_rvt L=2e-08 W=8.1e-08 nfin=3
M9 VDD C N_M8_d VDD pmos_rvt L=2e-08 W=8.1e-08 nfin=3
M10 N_M7_s C VDD VDD pmos_rvt L=2e-08 W=8.1e-08 nfin=3
M11 VDD B N_M7_s VDD pmos_rvt L=2e-08 W=8.1e-08 nfin=3
M12 Y N_M0_d VDD VDD pmos_rvt L=2e-08 W=8.1e-08 nfin=3
M13 Y N_M0_d VDD VDD pmos_rvt L=2e-08 W=8.1e-08 nfin=3
.ENDS

.SUBCKT MAJx3_ASAP7_75t_R A B C VDD VSS Y
M0 N_M0_d A N_M0_s VSS nmos_rvt L=2e-08 W=8.1e-08 nfin=3
M1 N_M1_d B N_M0_d VSS nmos_rvt L=2e-08 W=8.1e-08 nfin=3
M2 VSS C N_M1_d VSS nmos_rvt L=2e-08 W=8.1e-08 nfin=3
M3 N_M0_s C VSS VSS nmos_rvt L=2e-08 W=8.1e-08 nfin=3
M4 VSS B N_M0_s VSS nmos_rvt L=2e-08 W=8.1e-08 nfin=3
M5 Y N_M0_d VSS VSS nmos_rvt L=2e-08 W=8.1e-08 nfin=3
M6 Y N_M0_d VSS VSS nmos_rvt L=2e-08 W=8.1e-08 nfin=3
M7 Y N_M0_d VSS VSS nmos_rvt L=2e-08 W=8.1e-08 nfin=3
M8 N_M0_d A N_M8_s VDD pmos_rvt L=2e-08 W=8.1e-08 nfin=3
M9 N_M9_d B N_M0_d VDD pmos_rvt L=2e-08 W=8.1e-08 nfin=3
M10 VDD C N_M9_d VDD pmos_rvt L=2e-08 W=8.1e-08 nfin=3
M11 N_M8_s C VDD VDD pmos_rvt L=2e-08 W=8.1e-08 nfin=3
M12 VDD B N_M8_s VDD pmos_rvt L=2e-08 W=8.1e-08 nfin=3
M13 Y N_M0_d VDD VDD pmos_rvt L=2e-08 W=8.1e-08 nfin=3
M14 Y N_M0_d VDD VDD pmos_rvt L=2e-08 W=8.1e-08 nfin=3
M15 Y N_M0_d VDD VDD pmos_rvt L=2e-08 W=8.1e-08 nfin=3
.ENDS

.SUBCKT NAND2x1_ASAP7_75t_R A B VDD VSS Y
M0 VSS A N_M0_s VSS nmos_rvt L=2e-08 W=8.1e-08 nfin=3
M1 VSS A N_M0_s VSS nmos_rvt L=2e-08 W=8.1e-08 nfin=3
M2 Y B N_M0_s VSS nmos_rvt L=2e-08 W=8.1e-08 nfin=3
M3 Y B N_M0_s VSS nmos_rvt L=2e-08 W=8.1e-08 nfin=3
M4 VDD A Y VDD pmos_rvt L=2e-08 W=8.1e-08 nfin=3
M5 Y B VDD VDD pmos_rvt L=2e-08 W=8.1e-08 nfin=3
.ENDS

.SUBCKT NAND2x1p5_ASAP7_75t_R A B VDD VSS Y
M0 N_M0_d A VSS VSS nmos_rvt L=2e-08 W=8.1e-08 nfin=3
M1 N_M0_d A VSS VSS nmos_rvt L=2e-08 W=8.1e-08 nfin=3
M2 N_M0_d A VSS VSS nmos_rvt L=2e-08 W=8.1e-08 nfin=3
M3 Y B N_M0_d VSS nmos_rvt L=2e-08 W=8.1e-08 nfin=3
M4 Y B N_M0_d VSS nmos_rvt L=2e-08 W=8.1e-08 nfin=3
M5 Y B N_M0_d VSS nmos_rvt L=2e-08 W=8.1e-08 nfin=3
M6 VDD A Y VDD pmos_rvt L=2e-08 W=8.1e-08 nfin=3
M7 VDD A Y VDD pmos_rvt L=2e-08 W=5.4e-08 nfin=2
M8 VDD B Y VDD pmos_rvt L=2e-08 W=5.4e-08 nfin=2
M9 VDD B Y VDD pmos_rvt L=2e-08 W=8.1e-08 nfin=3
.ENDS

.SUBCKT NAND2x2_ASAP7_75t_R A B VDD VSS Y
M0 Y B N_M0_s VSS nmos_rvt L=2e-08 W=8.1e-08 nfin=3
M1 Y B N_M0_s VSS nmos_rvt L=2e-08 W=8.1e-08 nfin=3
M2 VSS A N_M0_s VSS nmos_rvt L=2e-08 W=8.1e-08 nfin=3
M3 VSS A N_M0_s VSS nmos_rvt L=2e-08 W=8.1e-08 nfin=3
M4 VSS A N_M0_s VSS nmos_rvt L=2e-08 W=8.1e-08 nfin=3
M5 VSS A N_M0_s VSS nmos_rvt L=2e-08 W=8.1e-08 nfin=3
M6 Y B N_M0_s VSS nmos_rvt L=2e-08 W=8.1e-08 nfin=3
M7 Y B N_M0_s VSS nmos_rvt L=2e-08 W=8.1e-08 nfin=3
M8 VDD B Y VDD pmos_rvt L=2e-08 W=8.1e-08 nfin=3
M9 Y A VDD VDD pmos_rvt L=2e-08 W=8.1e-08 nfin=3
M10 Y A VDD VDD pmos_rvt L=2e-08 W=8.1e-08 nfin=3
M11 VDD B Y VDD pmos_rvt L=2e-08 W=8.1e-08 nfin=3
.ENDS

.SUBCKT NAND2xp33_ASAP7_75t_R A B VDD VSS Y
M0 N_M0_d A VSS VSS nmos_rvt L=2e-08 W=5.4e-08 nfin=2
M1 Y B N_M0_d VSS nmos_rvt L=2e-08 W=5.4e-08 nfin=2
M2 Y A VDD VDD pmos_rvt L=2e-08 W=2.7e-08 nfin=1
M3 VDD B Y VDD pmos_rvt L=2e-08 W=2.7e-08 nfin=1
.ENDS

.SUBCKT NAND2xp5_ASAP7_75t_R A B VDD VSS Y
M0 N_M0_d A VSS VSS nmos_rvt L=2e-08 W=8.1e-08 nfin=3
M1 Y B N_M0_d VSS nmos_rvt L=2e-08 W=8.1e-08 nfin=3
M2 Y A VDD VDD pmos_rvt L=2e-08 W=5.4e-08 nfin=2
M3 VDD B Y VDD pmos_rvt L=2e-08 W=5.4e-08 nfin=2
.ENDS

.SUBCKT NAND2xp67_ASAP7_75t_R A B VDD VSS Y
M0 VSS A N_M0_s VSS nmos_rvt L=2e-08 W=5.4e-08 nfin=2
M1 VSS A N_M0_s VSS nmos_rvt L=2e-08 W=5.4e-08 nfin=2
M2 Y B N_M0_s VSS nmos_rvt L=2e-08 W=5.4e-08 nfin=2
M3 Y B N_M0_s VSS nmos_rvt L=2e-08 W=5.4e-08 nfin=2
M4 Y A VDD VDD pmos_rvt L=2e-08 W=5.4e-08 nfin=2
M5 VDD B Y VDD pmos_rvt L=2e-08 W=5.4e-08 nfin=2
.ENDS

.SUBCKT NAND3x1_ASAP7_75t_R A B C VDD VSS Y
M0 N_M0_d C VSS VSS nmos_rvt L=2e-08 W=8.1e-08 nfin=3
M1 N_M0_d C VSS VSS nmos_rvt L=2e-08 W=8.1e-08 nfin=3
M2 N_M0_d C VSS VSS nmos_rvt L=2e-08 W=8.1e-08 nfin=3
M3 N_M3_d B N_M0_d VSS nmos_rvt L=2e-08 W=8.1e-08 nfin=3
M4 N_M3_d B N_M0_d VSS nmos_rvt L=2e-08 W=8.1e-08 nfin=3
M5 N_M3_d B N_M0_d VSS nmos_rvt L=2e-08 W=8.1e-08 nfin=3
M6 Y A N_M3_d VSS nmos_rvt L=2e-08 W=8.1e-08 nfin=3
M7 Y A N_M3_d VSS nmos_rvt L=2e-08 W=8.1e-08 nfin=3
M8 Y A N_M3_d VSS nmos_rvt L=2e-08 W=8.1e-08 nfin=3
M9 Y C VDD VDD pmos_rvt L=2e-08 W=8.1e-08 nfin=3
M10 VDD B Y VDD pmos_rvt L=2e-08 W=8.1e-08 nfin=3
M11 Y A VDD VDD pmos_rvt L=2e-08 W=8.1e-08 nfin=3
.ENDS

.SUBCKT NAND3x2_ASAP7_75t_R A B C VDD VSS Y
M0 Y A N_M0_s VSS nmos_rvt L=2e-08 W=8.1e-08 nfin=3
M1 Y A N_M0_s VSS nmos_rvt L=2e-08 W=8.1e-08 nfin=3
M2 Y A N_M0_s VSS nmos_rvt L=2e-08 W=8.1e-08 nfin=3
M3 N_M0_s B N_M3_s VSS nmos_rvt L=2e-08 W=8.1e-08 nfin=3
M4 N_M0_s B N_M3_s VSS nmos_rvt L=2e-08 W=8.1e-08 nfin=3
M5 N_M0_s B N_M3_s VSS nmos_rvt L=2e-08 W=8.1e-08 nfin=3
M6 VSS C N_M3_s VSS nmos_rvt L=2e-08 W=8.1e-08 nfin=3
M7 VSS C N_M3_s VSS nmos_rvt L=2e-08 W=8.1e-08 nfin=3
M8 VSS C N_M3_s VSS nmos_rvt L=2e-08 W=8.1e-08 nfin=3
M9 VSS C N_M3_s VSS nmos_rvt L=2e-08 W=8.1e-08 nfin=3
M10 VSS C N_M3_s VSS nmos_rvt L=2e-08 W=8.1e-08 nfin=3
M11 VSS C N_M3_s VSS nmos_rvt L=2e-08 W=8.1e-08 nfin=3
M12 N_M12_d B N_M3_s VSS nmos_rvt L=2e-08 W=8.1e-08 nfin=3
M13 N_M12_d B N_M3_s VSS nmos_rvt L=2e-08 W=8.1e-08 nfin=3
M14 N_M12_d B N_M3_s VSS nmos_rvt L=2e-08 W=8.1e-08 nfin=3
M15 Y A N_M12_d VSS nmos_rvt L=2e-08 W=8.1e-08 nfin=3
M16 Y A N_M12_d VSS nmos_rvt L=2e-08 W=8.1e-08 nfin=3
M17 Y A N_M12_d VSS nmos_rvt L=2e-08 W=8.1e-08 nfin=3
M18 VDD A Y VDD pmos_rvt L=2e-08 W=8.1e-08 nfin=3
M19 Y B VDD VDD pmos_rvt L=2e-08 W=8.1e-08 nfin=3
M20 VDD C Y VDD pmos_rvt L=2e-08 W=8.1e-08 nfin=3
M21 VDD C Y VDD pmos_rvt L=2e-08 W=8.1e-08 nfin=3
M22 Y B VDD VDD pmos_rvt L=2e-08 W=8.1e-08 nfin=3
M23 VDD A Y VDD pmos_rvt L=2e-08 W=8.1e-08 nfin=3
.ENDS

.SUBCKT NAND3xp33_ASAP7_75t_R A B C VDD VSS Y
M0 N_M0_d A Y VSS nmos_rvt L=2e-08 W=8.1e-08 nfin=3
M1 N_M1_d B N_M0_d VSS nmos_rvt L=2e-08 W=8.1e-08 nfin=3
M2 VSS C N_M1_d VSS nmos_rvt L=2e-08 W=8.1e-08 nfin=3
M3 VDD A Y VDD pmos_rvt L=2e-08 W=5.4e-08 nfin=2
M4 Y B VDD VDD pmos_rvt L=2e-08 W=5.4e-08 nfin=2
M5 VDD C Y VDD pmos_rvt L=2e-08 W=5.4e-08 nfin=2
.ENDS

.SUBCKT NAND4xp25_ASAP7_75t_R A B C D VDD VSS Y
M0 N_M0_d D VSS VSS nmos_rvt L=2e-08 W=8.1e-08 nfin=3
M1 N_M1_d C N_M0_d VSS nmos_rvt L=2e-08 W=8.1e-08 nfin=3
M2 N_M2_d B N_M1_d VSS nmos_rvt L=2e-08 W=8.1e-08 nfin=3
M3 Y A N_M2_d VSS nmos_rvt L=2e-08 W=8.1e-08 nfin=3
M4 VDD D Y VDD pmos_rvt L=2e-08 W=5.4e-08 nfin=2
M5 Y C VDD VDD pmos_rvt L=2e-08 W=5.4e-08 nfin=2
M6 VDD B Y VDD pmos_rvt L=2e-08 W=5.4e-08 nfin=2
M7 Y A VDD VDD pmos_rvt L=2e-08 W=5.4e-08 nfin=2
.ENDS

.SUBCKT NAND4xp75_ASAP7_75t_R A B C D VDD VSS Y
M0 N_M0_d D VSS VSS nmos_rvt L=2e-08 W=8.1e-08 nfin=3
M1 N_M0_d D VSS VSS nmos_rvt L=2e-08 W=8.1e-08 nfin=3
M2 N_M0_d D VSS VSS nmos_rvt L=2e-08 W=8.1e-08 nfin=3
M3 N_M3_d C N_M0_d VSS nmos_rvt L=2e-08 W=8.1e-08 nfin=3
M4 N_M3_d C N_M0_d VSS nmos_rvt L=2e-08 W=8.1e-08 nfin=3
M5 N_M3_d C N_M0_d VSS nmos_rvt L=2e-08 W=8.1e-08 nfin=3
M6 N_M6_d B N_M3_d VSS nmos_rvt L=2e-08 W=8.1e-08 nfin=3
M7 N_M6_d B N_M3_d VSS nmos_rvt L=2e-08 W=8.1e-08 nfin=3
M8 N_M6_d B N_M3_d VSS nmos_rvt L=2e-08 W=8.1e-08 nfin=3
M9 Y A N_M6_d VSS nmos_rvt L=2e-08 W=8.1e-08 nfin=3
M10 Y A N_M6_d VSS nmos_rvt L=2e-08 W=8.1e-08 nfin=3
M11 Y A N_M6_d VSS nmos_rvt L=2e-08 W=8.1e-08 nfin=3
M12 Y D VDD VDD pmos_rvt L=2e-08 W=5.4e-08 nfin=2
M13 Y D VDD VDD pmos_rvt L=2e-08 W=5.4e-08 nfin=2
M14 Y D VDD VDD pmos_rvt L=2e-08 W=5.4e-08 nfin=2
M15 VDD C Y VDD pmos_rvt L=2e-08 W=5.4e-08 nfin=2
M16 VDD C Y VDD pmos_rvt L=2e-08 W=5.4e-08 nfin=2
M17 VDD C Y VDD pmos_rvt L=2e-08 W=5.4e-08 nfin=2
M18 Y B VDD VDD pmos_rvt L=2e-08 W=5.4e-08 nfin=2
M19 Y B VDD VDD pmos_rvt L=2e-08 W=5.4e-08 nfin=2
M20 Y B VDD VDD pmos_rvt L=2e-08 W=5.4e-08 nfin=2
M21 VDD A Y VDD pmos_rvt L=2e-08 W=5.4e-08 nfin=2
M22 VDD A Y VDD pmos_rvt L=2e-08 W=5.4e-08 nfin=2
M23 VDD A Y VDD pmos_rvt L=2e-08 W=5.4e-08 nfin=2
.ENDS

.SUBCKT NAND5xp2_ASAP7_75t_R A B C D E VDD VSS Y
M0 N_M0_d A Y VSS nmos_rvt L=2e-08 W=8.1e-08 nfin=3
M1 N_M1_d B N_M0_d VSS nmos_rvt L=2e-08 W=8.1e-08 nfin=3
M2 N_M2_d C N_M1_d VSS nmos_rvt L=2e-08 W=8.1e-08 nfin=3
M3 N_M3_d D N_M2_d VSS nmos_rvt L=2e-08 W=8.1e-08 nfin=3
M4 VSS E N_M3_d VSS nmos_rvt L=2e-08 W=8.1e-08 nfin=3
M5 VDD A Y VDD pmos_rvt L=2e-08 W=5.4e-08 nfin=2
M6 Y B VDD VDD pmos_rvt L=2e-08 W=5.4e-08 nfin=2
M7 VDD C Y VDD pmos_rvt L=2e-08 W=5.4e-08 nfin=2
M8 Y D VDD VDD pmos_rvt L=2e-08 W=5.4e-08 nfin=2
M9 VDD E Y VDD pmos_rvt L=2e-08 W=5.4e-08 nfin=2
.ENDS

.SUBCKT NOR2x1_ASAP7_75t_R A B VDD VSS Y
M0 VSS A Y VSS nmos_rvt L=2e-08 W=8.1e-08 nfin=3
M1 Y B VSS VSS nmos_rvt L=2e-08 W=8.1e-08 nfin=3
M2 VDD A N_M2_s VDD pmos_rvt L=2e-08 W=8.1e-08 nfin=3
M3 VDD A N_M2_s VDD pmos_rvt L=2e-08 W=8.1e-08 nfin=3
M4 Y B N_M2_s VDD pmos_rvt L=2e-08 W=8.1e-08 nfin=3
M5 Y B N_M2_s VDD pmos_rvt L=2e-08 W=8.1e-08 nfin=3
.ENDS

.SUBCKT NOR2x1p5_ASAP7_75t_R A B VDD VSS Y
M0 VSS A Y VSS nmos_rvt L=2e-08 W=8.1e-08 nfin=3
M1 VSS A Y VSS nmos_rvt L=2e-08 W=5.4e-08 nfin=2
M2 VSS B Y VSS nmos_rvt L=2e-08 W=5.4e-08 nfin=2
M3 VSS B Y VSS nmos_rvt L=2e-08 W=8.1e-08 nfin=3
M4 N_M4_d A VDD VDD pmos_rvt L=2e-08 W=8.1e-08 nfin=3
M5 N_M4_d A VDD VDD pmos_rvt L=2e-08 W=8.1e-08 nfin=3
M6 N_M4_d A VDD VDD pmos_rvt L=2e-08 W=8.1e-08 nfin=3
M7 Y B N_M4_d VDD pmos_rvt L=2e-08 W=8.1e-08 nfin=3
M8 Y B N_M4_d VDD pmos_rvt L=2e-08 W=8.1e-08 nfin=3
M9 Y B N_M4_d VDD pmos_rvt L=2e-08 W=8.1e-08 nfin=3
.ENDS

.SUBCKT NOR2x2_ASAP7_75t_R A B VDD VSS Y
M0 VSS B Y VSS nmos_rvt L=2e-08 W=8.1e-08 nfin=3
M1 Y A VSS VSS nmos_rvt L=2e-08 W=8.1e-08 nfin=3
M2 Y A VSS VSS nmos_rvt L=2e-08 W=8.1e-08 nfin=3
M3 VSS B Y VSS nmos_rvt L=2e-08 W=8.1e-08 nfin=3
M4 Y B N_M4_s VDD pmos_rvt L=2e-08 W=8.1e-08 nfin=3
M5 Y B N_M4_s VDD pmos_rvt L=2e-08 W=8.1e-08 nfin=3
M6 VDD A N_M4_s VDD pmos_rvt L=2e-08 W=8.1e-08 nfin=3
M7 VDD A N_M4_s VDD pmos_rvt L=2e-08 W=8.1e-08 nfin=3
M8 VDD A N_M4_s VDD pmos_rvt L=2e-08 W=8.1e-08 nfin=3
M9 VDD A N_M4_s VDD pmos_rvt L=2e-08 W=8.1e-08 nfin=3
M10 Y B N_M4_s VDD pmos_rvt L=2e-08 W=8.1e-08 nfin=3
M11 Y B N_M4_s VDD pmos_rvt L=2e-08 W=8.1e-08 nfin=3
.ENDS

.SUBCKT NOR2xp33_ASAP7_75t_R A B VDD VSS Y
M0 Y A VSS VSS nmos_rvt L=2e-08 W=2.7e-08 nfin=1
M1 VSS B Y VSS nmos_rvt L=2e-08 W=2.7e-08 nfin=1
M2 N_M2_d A VDD VDD pmos_rvt L=2e-08 W=5.4e-08 nfin=2
M3 Y B N_M2_d VDD pmos_rvt L=2e-08 W=5.4e-08 nfin=2
.ENDS

.SUBCKT NOR2xp67_ASAP7_75t_R A B VDD VSS Y
M0 Y A VSS VSS nmos_rvt L=2e-08 W=5.4e-08 nfin=2
M1 VSS B Y VSS nmos_rvt L=2e-08 W=5.4e-08 nfin=2
M2 VDD A N_M2_s VDD pmos_rvt L=2e-08 W=5.4e-08 nfin=2
M3 VDD A N_M2_s VDD pmos_rvt L=2e-08 W=5.4e-08 nfin=2
M4 Y B N_M2_s VDD pmos_rvt L=2e-08 W=5.4e-08 nfin=2
M5 Y B N_M2_s VDD pmos_rvt L=2e-08 W=5.4e-08 nfin=2
.ENDS

.SUBCKT NOR3x1_ASAP7_75t_R A B C VDD VSS Y
M0 Y C VSS VSS nmos_rvt L=2e-08 W=8.1e-08 nfin=3
M1 VSS B Y VSS nmos_rvt L=2e-08 W=8.1e-08 nfin=3
M2 Y A VSS VSS nmos_rvt L=2e-08 W=8.1e-08 nfin=3
M3 N_M3_d C VDD VDD pmos_rvt L=2e-08 W=8.1e-08 nfin=3
M4 N_M3_d C VDD VDD pmos_rvt L=2e-08 W=8.1e-08 nfin=3
M5 N_M3_d C VDD VDD pmos_rvt L=2e-08 W=8.1e-08 nfin=3
M6 N_M6_d B N_M3_d VDD pmos_rvt L=2e-08 W=8.1e-08 nfin=3
M7 N_M6_d B N_M3_d VDD pmos_rvt L=2e-08 W=8.1e-08 nfin=3
M8 N_M6_d B N_M3_d VDD pmos_rvt L=2e-08 W=8.1e-08 nfin=3
M9 Y A N_M6_d VDD pmos_rvt L=2e-08 W=8.1e-08 nfin=3
M10 Y A N_M6_d VDD pmos_rvt L=2e-08 W=8.1e-08 nfin=3
M11 Y A N_M6_d VDD pmos_rvt L=2e-08 W=8.1e-08 nfin=3
.ENDS

.SUBCKT NOR3x2_ASAP7_75t_R A B C VDD VSS Y
M0 VSS A Y VSS nmos_rvt L=2e-08 W=8.1e-08 nfin=3
M1 Y B VSS VSS nmos_rvt L=2e-08 W=8.1e-08 nfin=3
M2 VSS C Y VSS nmos_rvt L=2e-08 W=8.1e-08 nfin=3
M3 VSS C Y VSS nmos_rvt L=2e-08 W=8.1e-08 nfin=3
M4 Y B VSS VSS nmos_rvt L=2e-08 W=8.1e-08 nfin=3
M5 VSS A Y VSS nmos_rvt L=2e-08 W=8.1e-08 nfin=3
M6 Y A N_M6_s VDD pmos_rvt L=2e-08 W=8.1e-08 nfin=3
M7 Y A N_M6_s VDD pmos_rvt L=2e-08 W=8.1e-08 nfin=3
M8 Y A N_M6_s VDD pmos_rvt L=2e-08 W=8.1e-08 nfin=3
M9 N_M6_s B N_M9_s VDD pmos_rvt L=2e-08 W=8.1e-08 nfin=3
M10 N_M6_s B N_M9_s VDD pmos_rvt L=2e-08 W=8.1e-08 nfin=3
M11 N_M6_s B N_M9_s VDD pmos_rvt L=2e-08 W=8.1e-08 nfin=3
M12 VDD C N_M9_s VDD pmos_rvt L=2e-08 W=8.1e-08 nfin=3
M13 VDD C N_M9_s VDD pmos_rvt L=2e-08 W=8.1e-08 nfin=3
M14 VDD C N_M9_s VDD pmos_rvt L=2e-08 W=8.1e-08 nfin=3
M15 VDD C N_M9_s VDD pmos_rvt L=2e-08 W=8.1e-08 nfin=3
M16 VDD C N_M9_s VDD pmos_rvt L=2e-08 W=8.1e-08 nfin=3
M17 VDD C N_M9_s VDD pmos_rvt L=2e-08 W=8.1e-08 nfin=3
M18 N_M18_d B N_M9_s VDD pmos_rvt L=2e-08 W=8.1e-08 nfin=3
M19 N_M18_d B N_M9_s VDD pmos_rvt L=2e-08 W=8.1e-08 nfin=3
M20 N_M18_d B N_M9_s VDD pmos_rvt L=2e-08 W=8.1e-08 nfin=3
M21 Y A N_M18_d VDD pmos_rvt L=2e-08 W=8.1e-08 nfin=3
M22 Y A N_M18_d VDD pmos_rvt L=2e-08 W=8.1e-08 nfin=3
M23 Y A N_M18_d VDD pmos_rvt L=2e-08 W=8.1e-08 nfin=3
.ENDS

.SUBCKT NOR3xp33_ASAP7_75t_R A B C VDD VSS Y
M0 VSS A Y VSS nmos_rvt L=2e-08 W=5.4e-08 nfin=2
M1 Y B VSS VSS nmos_rvt L=2e-08 W=5.4e-08 nfin=2
M2 VSS C Y VSS nmos_rvt L=2e-08 W=5.4e-08 nfin=2
M3 N_M3_d A Y VDD pmos_rvt L=2e-08 W=8.1e-08 nfin=3
M4 N_M4_d B N_M3_d VDD pmos_rvt L=2e-08 W=8.1e-08 nfin=3
M5 VDD C N_M4_d VDD pmos_rvt L=2e-08 W=8.1e-08 nfin=3
.ENDS

.SUBCKT NOR4xp25_ASAP7_75t_R A B C D VDD VSS Y
M0 VSS D Y VSS nmos_rvt L=2e-08 W=5.4e-08 nfin=2
M1 Y C VSS VSS nmos_rvt L=2e-08 W=5.4e-08 nfin=2
M2 VSS B Y VSS nmos_rvt L=2e-08 W=5.4e-08 nfin=2
M3 Y A VSS VSS nmos_rvt L=2e-08 W=5.4e-08 nfin=2
M4 N_M4_d D VDD VDD pmos_rvt L=2e-08 W=8.1e-08 nfin=3
M5 N_M5_d C N_M4_d VDD pmos_rvt L=2e-08 W=8.1e-08 nfin=3
M6 N_M6_d B N_M5_d VDD pmos_rvt L=2e-08 W=8.1e-08 nfin=3
M7 Y A N_M6_d VDD pmos_rvt L=2e-08 W=8.1e-08 nfin=3
.ENDS

.SUBCKT NOR4xp75_ASAP7_75t_R A B C D VDD VSS Y
M0 Y D VSS VSS nmos_rvt L=2e-08 W=5.4e-08 nfin=2
M1 Y D VSS VSS nmos_rvt L=2e-08 W=5.4e-08 nfin=2
M2 Y D VSS VSS nmos_rvt L=2e-08 W=5.4e-08 nfin=2
M3 VSS C Y VSS nmos_rvt L=2e-08 W=5.4e-08 nfin=2
M4 VSS C Y VSS nmos_rvt L=2e-08 W=5.4e-08 nfin=2
M5 VSS C Y VSS nmos_rvt L=2e-08 W=5.4e-08 nfin=2
M6 Y B VSS VSS nmos_rvt L=2e-08 W=5.4e-08 nfin=2
M7 Y B VSS VSS nmos_rvt L=2e-08 W=5.4e-08 nfin=2
M8 Y B VSS VSS nmos_rvt L=2e-08 W=5.4e-08 nfin=2
M9 VSS A Y VSS nmos_rvt L=2e-08 W=5.4e-08 nfin=2
M10 VSS A Y VSS nmos_rvt L=2e-08 W=5.4e-08 nfin=2
M11 VSS A Y VSS nmos_rvt L=2e-08 W=5.4e-08 nfin=2
M12 N_M12_d D VDD VDD pmos_rvt L=2e-08 W=8.1e-08 nfin=3
M13 N_M12_d D VDD VDD pmos_rvt L=2e-08 W=8.1e-08 nfin=3
M14 N_M12_d D VDD VDD pmos_rvt L=2e-08 W=8.1e-08 nfin=3
M15 N_M15_d C N_M12_d VDD pmos_rvt L=2e-08 W=8.1e-08 nfin=3
M16 N_M15_d C N_M12_d VDD pmos_rvt L=2e-08 W=8.1e-08 nfin=3
M17 N_M15_d C N_M12_d VDD pmos_rvt L=2e-08 W=8.1e-08 nfin=3
M18 N_M18_d B N_M15_d VDD pmos_rvt L=2e-08 W=8.1e-08 nfin=3
M19 N_M18_d B N_M15_d VDD pmos_rvt L=2e-08 W=8.1e-08 nfin=3
M20 N_M18_d B N_M15_d VDD pmos_rvt L=2e-08 W=8.1e-08 nfin=3
M21 Y A N_M18_d VDD pmos_rvt L=2e-08 W=8.1e-08 nfin=3
M22 Y A N_M18_d VDD pmos_rvt L=2e-08 W=8.1e-08 nfin=3
M23 Y A N_M18_d VDD pmos_rvt L=2e-08 W=8.1e-08 nfin=3
.ENDS

.SUBCKT NOR5xp2_ASAP7_75t_R A B C D E VDD VSS Y
M0 Y A VSS VSS nmos_rvt L=2e-08 W=5.4e-08 nfin=2
M1 VSS B Y VSS nmos_rvt L=2e-08 W=5.4e-08 nfin=2
M2 Y C VSS VSS nmos_rvt L=2e-08 W=5.4e-08 nfin=2
M3 VSS D Y VSS nmos_rvt L=2e-08 W=5.4e-08 nfin=2
M4 Y E VSS VSS nmos_rvt L=2e-08 W=5.4e-08 nfin=2
M5 N_M5_d A Y VDD pmos_rvt L=2e-08 W=8.1e-08 nfin=3
M6 N_M6_d B N_M5_d VDD pmos_rvt L=2e-08 W=8.1e-08 nfin=3
M7 N_M7_d C N_M6_d VDD pmos_rvt L=2e-08 W=8.1e-08 nfin=3
M8 N_M8_d D N_M7_d VDD pmos_rvt L=2e-08 W=8.1e-08 nfin=3
M9 VDD E N_M8_d VDD pmos_rvt L=2e-08 W=8.1e-08 nfin=3
.ENDS

.SUBCKT O2A1O1Ixp33_ASAP7_75t_R A1 A2 B C VDD VSS Y
M0 Y A2 N_M0_s VSS nmos_rvt L=2e-08 W=8.1e-08 nfin=3
M1 N_M0_s A1 Y VSS nmos_rvt L=2e-08 W=8.1e-08 nfin=3
M2 VSS B N_M0_s VSS nmos_rvt L=2e-08 W=8.1e-08 nfin=3
M3 Y C VSS VSS nmos_rvt L=2e-08 W=5.4e-08 nfin=2
M4 noxref_10 A2 noxref_8 VDD pmos_rvt L=2e-08 W=8.1e-08 nfin=3
M5 VDD A1 noxref_10 VDD pmos_rvt L=2e-08 W=8.1e-08 nfin=3
M6 noxref_8 B VDD VDD pmos_rvt L=2e-08 W=8.1e-08 nfin=3
M7 Y C noxref_8 VDD pmos_rvt L=2e-08 W=8.1e-08 nfin=3
.ENDS

.SUBCKT O2A1O1Ixp5_ASAP7_75t_R A1 A2 B C VDD VSS Y
M0 VSS A2 N_M0_s VSS nmos_rvt L=2e-08 W=8.1e-08 nfin=3
M1 N_M0_s A1 VSS VSS nmos_rvt L=2e-08 W=8.1e-08 nfin=3
M2 Y B N_M0_s VSS nmos_rvt L=2e-08 W=8.1e-08 nfin=3
M3 VSS C Y VSS nmos_rvt L=2e-08 W=5.4e-08 nfin=2
M4 noxref_7 A1 VDD VDD pmos_rvt L=2e-08 W=8.1e-08 nfin=3
M5 noxref_8 A2 noxref_7 VDD pmos_rvt L=2e-08 W=8.1e-08 nfin=3
M6 noxref_8 A2 noxref_7 VDD pmos_rvt L=2e-08 W=8.1e-08 nfin=3
M7 noxref_7 A1 VDD VDD pmos_rvt L=2e-08 W=8.1e-08 nfin=3
M8 noxref_8 B VDD VDD pmos_rvt L=2e-08 W=8.1e-08 nfin=3
M9 Y C noxref_8 VDD pmos_rvt L=2e-08 W=8.1e-08 nfin=3
.ENDS

.SUBCKT OA211x2_ASAP7_75t_R A1 A2 B C VDD VSS Y
M0 N_M0_d A2 noxref_8 VSS nmos_rvt L=2e-08 W=8.1e-08 nfin=3
M1 noxref_8 A1 N_M0_d VSS nmos_rvt L=2e-08 W=8.1e-08 nfin=3
M2 noxref_10 B noxref_8 VSS nmos_rvt L=2e-08 W=8.1e-08 nfin=3
M3 VSS C noxref_10 VSS nmos_rvt L=2e-08 W=8.1e-08 nfin=3
M4 Y N_M0_d VSS VSS nmos_rvt L=2e-08 W=8.1e-08 nfin=3
M5 Y N_M0_d VSS VSS nmos_rvt L=2e-08 W=8.1e-08 nfin=3
M6 noxref_11 A2 N_M0_d VDD pmos_rvt L=2e-08 W=5.4e-08 nfin=2
M7 VDD A1 noxref_11 VDD pmos_rvt L=2e-08 W=5.4e-08 nfin=2
M8 N_M0_d B VDD VDD pmos_rvt L=2e-08 W=2.7e-08 nfin=1
M9 VDD C N_M0_d VDD pmos_rvt L=2e-08 W=2.7e-08 nfin=1
M10 Y N_M0_d VDD VDD pmos_rvt L=2e-08 W=8.1e-08 nfin=3
M11 Y N_M0_d VDD VDD pmos_rvt L=2e-08 W=8.1e-08 nfin=3
.ENDS

.SUBCKT OA21x2_ASAP7_75t_R A1 A2 B VDD VSS Y
M0 N_M0_d A1 noxref_7 VSS nmos_rvt L=2e-08 W=8.1e-08 nfin=3
M1 noxref_7 A2 N_M0_d VSS nmos_rvt L=2e-08 W=8.1e-08 nfin=3
M2 VSS B noxref_7 VSS nmos_rvt L=2e-08 W=8.1e-08 nfin=3
M3 Y N_M0_d VSS VSS nmos_rvt L=2e-08 W=8.1e-08 nfin=3
M4 Y N_M0_d VSS VSS nmos_rvt L=2e-08 W=8.1e-08 nfin=3
M5 noxref_9 A1 VDD VDD pmos_rvt L=2e-08 W=8.1e-08 nfin=3
M6 N_M0_d A2 noxref_9 VDD pmos_rvt L=2e-08 W=8.1e-08 nfin=3
M7 VDD B N_M0_d VDD pmos_rvt L=2e-08 W=8.1e-08 nfin=3
M8 Y N_M0_d VDD VDD pmos_rvt L=2e-08 W=8.1e-08 nfin=3
M9 Y N_M0_d VDD VDD pmos_rvt L=2e-08 W=8.1e-08 nfin=3
.ENDS

.SUBCKT OA221x2_ASAP7_75t_R A1 A2 B1 B2 C VDD VSS Y
M0 Y N_M0_g VSS VSS nmos_rvt L=2e-08 W=8.1e-08 nfin=3
M1 Y N_M0_g VSS VSS nmos_rvt L=2e-08 W=8.1e-08 nfin=3
M2 noxref_10 A1 VSS VSS nmos_rvt L=2e-08 W=8.1e-08 nfin=3
M3 noxref_10 A1 VSS VSS nmos_rvt L=2e-08 W=8.1e-08 nfin=3
M4 noxref_10 A2 VSS VSS nmos_rvt L=2e-08 W=8.1e-08 nfin=3
M5 noxref_10 A2 VSS VSS nmos_rvt L=2e-08 W=8.1e-08 nfin=3
M6 noxref_10 B2 noxref_11 VSS nmos_rvt L=2e-08 W=8.1e-08 nfin=3
M7 noxref_10 B2 noxref_11 VSS nmos_rvt L=2e-08 W=8.1e-08 nfin=3
M8 noxref_10 B1 noxref_11 VSS nmos_rvt L=2e-08 W=8.1e-08 nfin=3
M9 noxref_10 B1 noxref_11 VSS nmos_rvt L=2e-08 W=8.1e-08 nfin=3
M10 N_M0_g C noxref_11 VSS nmos_rvt L=2e-08 W=8.1e-08 nfin=3
M11 N_M0_g C noxref_11 VSS nmos_rvt L=2e-08 W=8.1e-08 nfin=3
M12 Y N_M0_g VDD VDD pmos_rvt L=2e-08 W=8.1e-08 nfin=3
M13 Y N_M0_g VDD VDD pmos_rvt L=2e-08 W=8.1e-08 nfin=3
M14 noxref_12 A1 VDD VDD pmos_rvt L=2e-08 W=8.1e-08 nfin=3
M15 N_M0_g A2 noxref_12 VDD pmos_rvt L=2e-08 W=8.1e-08 nfin=3
M16 noxref_13 B2 N_M0_g VDD pmos_rvt L=2e-08 W=8.1e-08 nfin=3
M17 VDD B1 noxref_13 VDD pmos_rvt L=2e-08 W=8.1e-08 nfin=3
M18 N_M0_g C VDD VDD pmos_rvt L=2e-08 W=5.4e-08 nfin=2
.ENDS

.SUBCKT OA222x2_ASAP7_75t_R A1 A2 B1 B2 C1 C2 VDD VSS Y
M0 N_M0_d A1 noxref_10 VSS nmos_rvt L=2e-08 W=8.1e-08 nfin=3
M1 noxref_10 A2 N_M0_d VSS nmos_rvt L=2e-08 W=8.1e-08 nfin=3
M2 noxref_11 B2 noxref_10 VSS nmos_rvt L=2e-08 W=8.1e-08 nfin=3
M3 noxref_10 B1 noxref_11 VSS nmos_rvt L=2e-08 W=8.1e-08 nfin=3
M4 noxref_11 C1 VSS VSS nmos_rvt L=2e-08 W=8.1e-08 nfin=3
M5 VSS C2 noxref_11 VSS nmos_rvt L=2e-08 W=8.1e-08 nfin=3
M6 Y N_M0_d VSS VSS nmos_rvt L=2e-08 W=8.1e-08 nfin=3
M7 Y N_M0_d VSS VSS nmos_rvt L=2e-08 W=8.1e-08 nfin=3
M8 noxref_13 A1 N_M0_d VDD pmos_rvt L=2e-08 W=8.1e-08 nfin=3
M9 VDD A2 noxref_13 VDD pmos_rvt L=2e-08 W=8.1e-08 nfin=3
M10 noxref_14 B2 VDD VDD pmos_rvt L=2e-08 W=8.1e-08 nfin=3
M11 N_M0_d B1 noxref_14 VDD pmos_rvt L=2e-08 W=8.1e-08 nfin=3
M12 noxref_15 C1 N_M0_d VDD pmos_rvt L=2e-08 W=8.1e-08 nfin=3
M13 VDD C2 noxref_15 VDD pmos_rvt L=2e-08 W=8.1e-08 nfin=3
M14 Y N_M0_d VDD VDD pmos_rvt L=2e-08 W=8.1e-08 nfin=3
M15 Y N_M0_d VDD VDD pmos_rvt L=2e-08 W=8.1e-08 nfin=3
.ENDS

.SUBCKT OA22x2_ASAP7_75t_R A1 A2 B1 B2 VDD VSS Y
M0 Y N_M0_g VSS VSS nmos_rvt L=2e-08 W=8.1e-08 nfin=3
M1 Y N_M0_g VSS VSS nmos_rvt L=2e-08 W=8.1e-08 nfin=3
M2 N_M0_g A1 noxref_9 VSS nmos_rvt L=2e-08 W=8.1e-08 nfin=3
M3 noxref_9 A2 N_M0_g VSS nmos_rvt L=2e-08 W=8.1e-08 nfin=3
M4 VSS B2 noxref_9 VSS nmos_rvt L=2e-08 W=8.1e-08 nfin=3
M5 noxref_9 B1 VSS VSS nmos_rvt L=2e-08 W=8.1e-08 nfin=3
M6 Y N_M0_g VDD VDD pmos_rvt L=2e-08 W=8.1e-08 nfin=3
M7 Y N_M0_g VDD VDD pmos_rvt L=2e-08 W=8.1e-08 nfin=3
M8 noxref_10 A1 VDD VDD pmos_rvt L=2e-08 W=8.1e-08 nfin=3
M9 N_M0_g A2 noxref_10 VDD pmos_rvt L=2e-08 W=8.1e-08 nfin=3
M10 noxref_11 B2 N_M0_g VDD pmos_rvt L=2e-08 W=8.1e-08 nfin=3
M11 VDD B1 noxref_11 VDD pmos_rvt L=2e-08 W=8.1e-08 nfin=3
.ENDS

.SUBCKT OA31x2_ASAP7_75t_R A1 A2 A3 B1 VDD VSS Y
M0 noxref_9 A1 N_M0_s VSS nmos_rvt L=2e-08 W=8.1e-08 nfin=3
M1 N_M0_s A2 noxref_9 VSS nmos_rvt L=2e-08 W=8.1e-08 nfin=3
M2 noxref_9 A3 N_M0_s VSS nmos_rvt L=2e-08 W=8.1e-08 nfin=3
M3 VSS B1 noxref_9 VSS nmos_rvt L=2e-08 W=8.1e-08 nfin=3
M4 Y N_M0_s VSS VSS nmos_rvt L=2e-08 W=8.1e-08 nfin=3
M5 Y N_M0_s VSS VSS nmos_rvt L=2e-08 W=8.1e-08 nfin=3
M6 VDD A1 noxref_8 VDD pmos_rvt L=2e-08 W=8.1e-08 nfin=3
M7 VDD A1 noxref_8 VDD pmos_rvt L=2e-08 W=8.1e-08 nfin=3
M8 noxref_10 A2 noxref_8 VDD pmos_rvt L=2e-08 W=8.1e-08 nfin=3
M9 noxref_10 A2 noxref_8 VDD pmos_rvt L=2e-08 W=8.1e-08 nfin=3
M10 noxref_10 A3 N_M0_s VDD pmos_rvt L=2e-08 W=8.1e-08 nfin=3
M11 noxref_10 A3 N_M0_s VDD pmos_rvt L=2e-08 W=8.1e-08 nfin=3
M12 VDD B1 N_M0_s VDD pmos_rvt L=2e-08 W=5.4e-08 nfin=2
M13 Y N_M0_s VDD VDD pmos_rvt L=2e-08 W=8.1e-08 nfin=3
M14 Y N_M0_s VDD VDD pmos_rvt L=2e-08 W=8.1e-08 nfin=3
.ENDS

.SUBCKT OA331x1_ASAP7_75t_R A1 A2 A3 B1 B2 B3 C1 VDD VSS Y
M0 VSS N_M0_g Y VSS nmos_rvt L=2e-08 W=8.1e-08 nfin=3
M1 noxref_12 A3 VSS VSS nmos_rvt L=2e-08 W=8.1e-08 nfin=3
M2 VSS A2 noxref_12 VSS nmos_rvt L=2e-08 W=8.1e-08 nfin=3
M3 noxref_12 A1 VSS VSS nmos_rvt L=2e-08 W=8.1e-08 nfin=3
M4 noxref_13 B1 noxref_12 VSS nmos_rvt L=2e-08 W=8.1e-08 nfin=3
M5 noxref_12 B2 noxref_13 VSS nmos_rvt L=2e-08 W=8.1e-08 nfin=3
M6 noxref_13 B3 noxref_12 VSS nmos_rvt L=2e-08 W=8.1e-08 nfin=3
M7 N_M0_g C1 noxref_13 VSS nmos_rvt L=2e-08 W=8.1e-08 nfin=3
M8 VDD N_M0_g Y VDD pmos_rvt L=2e-08 W=8.1e-08 nfin=3
M9 noxref_14 A3 VDD VDD pmos_rvt L=2e-08 W=8.1e-08 nfin=3
M10 noxref_15 A2 noxref_14 VDD pmos_rvt L=2e-08 W=8.1e-08 nfin=3
M11 N_M0_g A1 noxref_15 VDD pmos_rvt L=2e-08 W=8.1e-08 nfin=3
M12 noxref_16 B1 N_M0_g VDD pmos_rvt L=2e-08 W=8.1e-08 nfin=3
M13 noxref_17 B2 noxref_16 VDD pmos_rvt L=2e-08 W=8.1e-08 nfin=3
M14 VDD B3 noxref_17 VDD pmos_rvt L=2e-08 W=8.1e-08 nfin=3
M15 N_M0_g C1 VDD VDD pmos_rvt L=2e-08 W=8.1e-08 nfin=3
.ENDS

.SUBCKT OA331x2_ASAP7_75t_R A1 A2 A3 B1 B2 B3 C1 VDD VSS Y
M0 Y N_M0_g VSS VSS nmos_rvt L=2e-08 W=8.1e-08 nfin=3
M1 Y N_M0_g VSS VSS nmos_rvt L=2e-08 W=8.1e-08 nfin=3
M2 noxref_12 A3 VSS VSS nmos_rvt L=2e-08 W=8.1e-08 nfin=3
M3 VSS A2 noxref_12 VSS nmos_rvt L=2e-08 W=8.1e-08 nfin=3
M4 noxref_12 A1 VSS VSS nmos_rvt L=2e-08 W=8.1e-08 nfin=3
M5 noxref_13 B1 noxref_12 VSS nmos_rvt L=2e-08 W=8.1e-08 nfin=3
M6 noxref_12 B2 noxref_13 VSS nmos_rvt L=2e-08 W=8.1e-08 nfin=3
M7 noxref_13 B3 noxref_12 VSS nmos_rvt L=2e-08 W=8.1e-08 nfin=3
M8 N_M0_g C1 noxref_13 VSS nmos_rvt L=2e-08 W=8.1e-08 nfin=3
M9 Y N_M0_g VDD VDD pmos_rvt L=2e-08 W=8.1e-08 nfin=3
M10 Y N_M0_g VDD VDD pmos_rvt L=2e-08 W=8.1e-08 nfin=3
M11 noxref_14 A3 VDD VDD pmos_rvt L=2e-08 W=8.1e-08 nfin=3
M12 noxref_15 A2 noxref_14 VDD pmos_rvt L=2e-08 W=8.1e-08 nfin=3
M13 N_M0_g A1 noxref_15 VDD pmos_rvt L=2e-08 W=8.1e-08 nfin=3
M14 noxref_16 B1 N_M0_g VDD pmos_rvt L=2e-08 W=8.1e-08 nfin=3
M15 noxref_17 B2 noxref_16 VDD pmos_rvt L=2e-08 W=8.1e-08 nfin=3
M16 VDD B3 noxref_17 VDD pmos_rvt L=2e-08 W=8.1e-08 nfin=3
M17 N_M0_g C1 VDD VDD pmos_rvt L=2e-08 W=8.1e-08 nfin=3
.ENDS

.SUBCKT OA332x1_ASAP7_75t_R A1 A2 A3 B1 B2 B3 C1 C2 VDD VSS Y
M0 VSS N_M0_g Y VSS nmos_rvt L=2e-08 W=8.1e-08 nfin=3
M1 noxref_13 A3 VSS VSS nmos_rvt L=2e-08 W=8.1e-08 nfin=3
M2 VSS A2 noxref_13 VSS nmos_rvt L=2e-08 W=8.1e-08 nfin=3
M3 noxref_13 A1 VSS VSS nmos_rvt L=2e-08 W=8.1e-08 nfin=3
M4 noxref_14 B1 noxref_13 VSS nmos_rvt L=2e-08 W=8.1e-08 nfin=3
M5 noxref_13 B2 noxref_14 VSS nmos_rvt L=2e-08 W=8.1e-08 nfin=3
M6 noxref_14 B3 noxref_13 VSS nmos_rvt L=2e-08 W=8.1e-08 nfin=3
M7 N_M0_g C2 noxref_14 VSS nmos_rvt L=2e-08 W=8.1e-08 nfin=3
M8 noxref_14 C1 N_M0_g VSS nmos_rvt L=2e-08 W=8.1e-08 nfin=3
M9 VDD N_M0_g Y VDD pmos_rvt L=2e-08 W=8.1e-08 nfin=3
M10 noxref_15 A3 VDD VDD pmos_rvt L=2e-08 W=8.1e-08 nfin=3
M11 noxref_16 A2 noxref_15 VDD pmos_rvt L=2e-08 W=8.1e-08 nfin=3
M12 N_M0_g A1 noxref_16 VDD pmos_rvt L=2e-08 W=8.1e-08 nfin=3
M13 noxref_17 B1 N_M0_g VDD pmos_rvt L=2e-08 W=8.1e-08 nfin=3
M14 noxref_18 B2 noxref_17 VDD pmos_rvt L=2e-08 W=8.1e-08 nfin=3
M15 VDD B3 noxref_18 VDD pmos_rvt L=2e-08 W=8.1e-08 nfin=3
M16 noxref_19 C2 VDD VDD pmos_rvt L=2e-08 W=8.1e-08 nfin=3
M17 N_M0_g C1 noxref_19 VDD pmos_rvt L=2e-08 W=8.1e-08 nfin=3
.ENDS

.SUBCKT OA332x2_ASAP7_75t_R A1 A2 A3 B1 B2 B3 C1 C2 VDD VSS Y
M0 Y N_M0_g VSS VSS nmos_rvt L=2e-08 W=8.1e-08 nfin=3
M1 Y N_M0_g VSS VSS nmos_rvt L=2e-08 W=8.1e-08 nfin=3
M2 noxref_13 A3 VSS VSS nmos_rvt L=2e-08 W=8.1e-08 nfin=3
M3 VSS A2 noxref_13 VSS nmos_rvt L=2e-08 W=8.1e-08 nfin=3
M4 noxref_13 A1 VSS VSS nmos_rvt L=2e-08 W=8.1e-08 nfin=3
M5 noxref_14 B1 noxref_13 VSS nmos_rvt L=2e-08 W=8.1e-08 nfin=3
M6 noxref_13 B2 noxref_14 VSS nmos_rvt L=2e-08 W=8.1e-08 nfin=3
M7 noxref_14 B3 noxref_13 VSS nmos_rvt L=2e-08 W=8.1e-08 nfin=3
M8 N_M0_g C2 noxref_14 VSS nmos_rvt L=2e-08 W=8.1e-08 nfin=3
M9 noxref_14 C1 N_M0_g VSS nmos_rvt L=2e-08 W=8.1e-08 nfin=3
M10 Y N_M0_g VDD VDD pmos_rvt L=2e-08 W=8.1e-08 nfin=3
M11 Y N_M0_g VDD VDD pmos_rvt L=2e-08 W=8.1e-08 nfin=3
M12 noxref_15 A3 VDD VDD pmos_rvt L=2e-08 W=8.1e-08 nfin=3
M13 noxref_16 A2 noxref_15 VDD pmos_rvt L=2e-08 W=8.1e-08 nfin=3
M14 N_M0_g A1 noxref_16 VDD pmos_rvt L=2e-08 W=8.1e-08 nfin=3
M15 noxref_17 B1 N_M0_g VDD pmos_rvt L=2e-08 W=8.1e-08 nfin=3
M16 noxref_18 B2 noxref_17 VDD pmos_rvt L=2e-08 W=8.1e-08 nfin=3
M17 VDD B3 noxref_18 VDD pmos_rvt L=2e-08 W=8.1e-08 nfin=3
M18 noxref_19 C2 VDD VDD pmos_rvt L=2e-08 W=8.1e-08 nfin=3
M19 N_M0_g C1 noxref_19 VDD pmos_rvt L=2e-08 W=8.1e-08 nfin=3
.ENDS

.SUBCKT OA333x1_ASAP7_75t_R A1 A2 A3 B1 B2 B3 C1 C2 C3 VDD VSS Y
M0 VSS N_M0_g Y VSS nmos_rvt L=2e-08 W=8.1e-08 nfin=3
M1 noxref_14 C3 VSS VSS nmos_rvt L=2e-08 W=8.1e-08 nfin=3
M2 VSS C2 noxref_14 VSS nmos_rvt L=2e-08 W=8.1e-08 nfin=3
M3 noxref_14 C1 VSS VSS nmos_rvt L=2e-08 W=8.1e-08 nfin=3
M4 noxref_15 B1 noxref_14 VSS nmos_rvt L=2e-08 W=8.1e-08 nfin=3
M5 noxref_14 B2 noxref_15 VSS nmos_rvt L=2e-08 W=8.1e-08 nfin=3
M6 noxref_15 B3 noxref_14 VSS nmos_rvt L=2e-08 W=8.1e-08 nfin=3
M7 N_M0_g A3 noxref_15 VSS nmos_rvt L=2e-08 W=8.1e-08 nfin=3
M8 noxref_15 A2 N_M0_g VSS nmos_rvt L=2e-08 W=8.1e-08 nfin=3
M9 N_M0_g A1 noxref_15 VSS nmos_rvt L=2e-08 W=8.1e-08 nfin=3
M10 VDD N_M0_g Y VDD pmos_rvt L=2e-08 W=8.1e-08 nfin=3
M11 noxref_16 C3 VDD VDD pmos_rvt L=2e-08 W=8.1e-08 nfin=3
M12 noxref_17 C2 noxref_16 VDD pmos_rvt L=2e-08 W=8.1e-08 nfin=3
M13 N_M0_g C1 noxref_17 VDD pmos_rvt L=2e-08 W=8.1e-08 nfin=3
M14 noxref_18 B1 N_M0_g VDD pmos_rvt L=2e-08 W=8.1e-08 nfin=3
M15 noxref_19 B2 noxref_18 VDD pmos_rvt L=2e-08 W=8.1e-08 nfin=3
M16 VDD B3 noxref_19 VDD pmos_rvt L=2e-08 W=8.1e-08 nfin=3
M17 noxref_20 A3 VDD VDD pmos_rvt L=2e-08 W=8.1e-08 nfin=3
M18 noxref_21 A2 noxref_20 VDD pmos_rvt L=2e-08 W=8.1e-08 nfin=3
M19 N_M0_g A1 noxref_21 VDD pmos_rvt L=2e-08 W=8.1e-08 nfin=3
.ENDS

.SUBCKT OA333x2_ASAP7_75t_R A1 A2 A3 B1 B2 B3 C1 C2 C3 VDD VSS Y
M0 Y N_M0_g VSS VSS nmos_rvt L=2e-08 W=8.1e-08 nfin=3
M1 Y N_M0_g VSS VSS nmos_rvt L=2e-08 W=8.1e-08 nfin=3
M2 noxref_14 C3 VSS VSS nmos_rvt L=2e-08 W=8.1e-08 nfin=3
M3 VSS C2 noxref_14 VSS nmos_rvt L=2e-08 W=8.1e-08 nfin=3
M4 noxref_14 C1 VSS VSS nmos_rvt L=2e-08 W=8.1e-08 nfin=3
M5 noxref_15 B1 noxref_14 VSS nmos_rvt L=2e-08 W=8.1e-08 nfin=3
M6 noxref_14 B2 noxref_15 VSS nmos_rvt L=2e-08 W=8.1e-08 nfin=3
M7 noxref_15 B3 noxref_14 VSS nmos_rvt L=2e-08 W=8.1e-08 nfin=3
M8 N_M0_g A3 noxref_15 VSS nmos_rvt L=2e-08 W=8.1e-08 nfin=3
M9 noxref_15 A2 N_M0_g VSS nmos_rvt L=2e-08 W=8.1e-08 nfin=3
M10 N_M0_g A1 noxref_15 VSS nmos_rvt L=2e-08 W=8.1e-08 nfin=3
M11 Y N_M0_g VDD VDD pmos_rvt L=2e-08 W=8.1e-08 nfin=3
M12 Y N_M0_g VDD VDD pmos_rvt L=2e-08 W=8.1e-08 nfin=3
M13 noxref_16 C3 VDD VDD pmos_rvt L=2e-08 W=8.1e-08 nfin=3
M14 noxref_17 C2 noxref_16 VDD pmos_rvt L=2e-08 W=8.1e-08 nfin=3
M15 N_M0_g C1 noxref_17 VDD pmos_rvt L=2e-08 W=8.1e-08 nfin=3
M16 noxref_18 B1 N_M0_g VDD pmos_rvt L=2e-08 W=8.1e-08 nfin=3
M17 noxref_19 B2 noxref_18 VDD pmos_rvt L=2e-08 W=8.1e-08 nfin=3
M18 VDD B3 noxref_19 VDD pmos_rvt L=2e-08 W=8.1e-08 nfin=3
M19 noxref_20 A3 VDD VDD pmos_rvt L=2e-08 W=8.1e-08 nfin=3
M20 noxref_21 A2 noxref_20 VDD pmos_rvt L=2e-08 W=8.1e-08 nfin=3
M21 N_M0_g A1 noxref_21 VDD pmos_rvt L=2e-08 W=8.1e-08 nfin=3
.ENDS

.SUBCKT OA33x2_ASAP7_75t_R A1 A2 A3 B1 B2 B3 VDD VSS Y
M0 Y N_M0_g VSS VSS nmos_rvt L=2e-08 W=8.1e-08 nfin=3
M1 Y N_M0_g VSS VSS nmos_rvt L=2e-08 W=8.1e-08 nfin=3
M2 noxref_11 A1 VSS VSS nmos_rvt L=2e-08 W=8.1e-08 nfin=3
M3 VSS A2 noxref_11 VSS nmos_rvt L=2e-08 W=8.1e-08 nfin=3
M4 noxref_11 A3 VSS VSS nmos_rvt L=2e-08 W=8.1e-08 nfin=3
M5 N_M0_g B3 noxref_11 VSS nmos_rvt L=2e-08 W=8.1e-08 nfin=3
M6 noxref_11 B2 N_M0_g VSS nmos_rvt L=2e-08 W=8.1e-08 nfin=3
M7 N_M0_g B1 noxref_11 VSS nmos_rvt L=2e-08 W=8.1e-08 nfin=3
M8 Y N_M0_g VDD VDD pmos_rvt L=2e-08 W=8.1e-08 nfin=3
M9 Y N_M0_g VDD VDD pmos_rvt L=2e-08 W=8.1e-08 nfin=3
M10 noxref_12 A1 VDD VDD pmos_rvt L=2e-08 W=8.1e-08 nfin=3
M11 noxref_13 A2 noxref_12 VDD pmos_rvt L=2e-08 W=8.1e-08 nfin=3
M12 N_M0_g A3 noxref_13 VDD pmos_rvt L=2e-08 W=8.1e-08 nfin=3
M13 noxref_14 B3 N_M0_g VDD pmos_rvt L=2e-08 W=8.1e-08 nfin=3
M14 noxref_15 B2 noxref_14 VDD pmos_rvt L=2e-08 W=8.1e-08 nfin=3
M15 VDD B1 noxref_15 VDD pmos_rvt L=2e-08 W=8.1e-08 nfin=3
.ENDS

.SUBCKT OAI211xp5_ASAP7_75t_R A1 A2 B C VDD VSS Y
M0 Y A2 noxref_7 VSS nmos_rvt L=2e-08 W=8.1e-08 nfin=3
M1 noxref_7 A1 Y VSS nmos_rvt L=2e-08 W=8.1e-08 nfin=3
M2 noxref_9 B noxref_7 VSS nmos_rvt L=2e-08 W=8.1e-08 nfin=3
M3 VSS C noxref_9 VSS nmos_rvt L=2e-08 W=8.1e-08 nfin=3
M4 noxref_10 A2 Y VDD pmos_rvt L=2e-08 W=5.4e-08 nfin=2
M5 VDD A1 noxref_10 VDD pmos_rvt L=2e-08 W=5.4e-08 nfin=2
M6 Y B VDD VDD pmos_rvt L=2e-08 W=5.4e-08 nfin=2
M7 VDD C Y VDD pmos_rvt L=2e-08 W=5.4e-08 nfin=2
.ENDS

.SUBCKT OAI21x1_ASAP7_75t_R A1 A2 B VDD VSS Y
M0 noxref_6 B Y VSS nmos_rvt L=2e-08 W=8.1e-08 nfin=3
M1 VSS A1 noxref_6 VSS nmos_rvt L=2e-08 W=8.1e-08 nfin=3
M2 noxref_6 A2 VSS VSS nmos_rvt L=2e-08 W=8.1e-08 nfin=3
M3 noxref_6 A2 VSS VSS nmos_rvt L=2e-08 W=8.1e-08 nfin=3
M4 VSS A1 noxref_6 VSS nmos_rvt L=2e-08 W=8.1e-08 nfin=3
M5 noxref_6 B Y VSS nmos_rvt L=2e-08 W=8.1e-08 nfin=3
M6 Y B VDD VDD pmos_rvt L=2e-08 W=8.1e-08 nfin=3
M7 Y A1 noxref_8 VDD pmos_rvt L=2e-08 W=8.1e-08 nfin=3
M8 noxref_8 A2 VDD VDD pmos_rvt L=2e-08 W=8.1e-08 nfin=3
M9 noxref_9 A2 VDD VDD pmos_rvt L=2e-08 W=8.1e-08 nfin=3
M10 Y A1 noxref_9 VDD pmos_rvt L=2e-08 W=8.1e-08 nfin=3
M11 Y B VDD VDD pmos_rvt L=2e-08 W=8.1e-08 nfin=3
.ENDS

.SUBCKT OAI21xp33_ASAP7_75t_R A1 A2 B VDD VSS Y
M0 Y A1 noxref_6 VSS nmos_rvt L=2e-08 W=5.4e-08 nfin=2
M1 noxref_6 A2 Y VSS nmos_rvt L=2e-08 W=5.4e-08 nfin=2
M2 VSS B noxref_6 VSS nmos_rvt L=2e-08 W=5.4e-08 nfin=2
M3 noxref_8 A1 VDD VDD pmos_rvt L=2e-08 W=5.4e-08 nfin=2
M4 Y A2 noxref_8 VDD pmos_rvt L=2e-08 W=5.4e-08 nfin=2
M5 VDD B Y VDD pmos_rvt L=2e-08 W=5.4e-08 nfin=2
.ENDS

.SUBCKT OAI21xp5_ASAP7_75t_R A1 A2 B VDD VSS Y
M0 Y A1 noxref_6 VSS nmos_rvt L=2e-08 W=8.1e-08 nfin=3
M1 noxref_6 A2 Y VSS nmos_rvt L=2e-08 W=8.1e-08 nfin=3
M2 VSS B noxref_6 VSS nmos_rvt L=2e-08 W=8.1e-08 nfin=3
M3 noxref_8 A1 VDD VDD pmos_rvt L=2e-08 W=8.1e-08 nfin=3
M4 Y A2 noxref_8 VDD pmos_rvt L=2e-08 W=8.1e-08 nfin=3
M5 VDD B Y VDD pmos_rvt L=2e-08 W=8.1e-08 nfin=3
.ENDS

.SUBCKT OAI221xp5_ASAP7_75t_R A1 A2 B1 B2 C VDD VSS Y
M0 Y B1 noxref_9 VSS nmos_rvt L=2e-08 W=8.1e-08 nfin=3
M1 noxref_9 B2 Y VSS nmos_rvt L=2e-08 W=8.1e-08 nfin=3
M2 noxref_10 C noxref_9 VSS nmos_rvt L=2e-08 W=8.1e-08 nfin=3
M3 VSS A1 noxref_10 VSS nmos_rvt L=2e-08 W=8.1e-08 nfin=3
M4 noxref_10 A2 VSS VSS nmos_rvt L=2e-08 W=8.1e-08 nfin=3
M5 noxref_11 B1 Y VDD pmos_rvt L=2e-08 W=5.4e-08 nfin=2
M6 VDD B2 noxref_11 VDD pmos_rvt L=2e-08 W=5.4e-08 nfin=2
M7 Y C VDD VDD pmos_rvt L=2e-08 W=5.4e-08 nfin=2
M8 noxref_12 A1 Y VDD pmos_rvt L=2e-08 W=5.4e-08 nfin=2
M9 VDD A2 noxref_12 VDD pmos_rvt L=2e-08 W=5.4e-08 nfin=2
.ENDS

.SUBCKT OAI222xp33_ASAP7_75t_R A1 A2 B1 B2 C1 C2 VDD VSS Y
M0 Y A1 noxref_9 VSS nmos_rvt L=2e-08 W=8.1e-08 nfin=3
M1 noxref_9 A2 Y VSS nmos_rvt L=2e-08 W=8.1e-08 nfin=3
M2 noxref_10 B2 noxref_9 VSS nmos_rvt L=2e-08 W=8.1e-08 nfin=3
M3 noxref_9 B1 noxref_10 VSS nmos_rvt L=2e-08 W=8.1e-08 nfin=3
M4 noxref_10 C1 VSS VSS nmos_rvt L=2e-08 W=8.1e-08 nfin=3
M5 VSS C2 noxref_10 VSS nmos_rvt L=2e-08 W=8.1e-08 nfin=3
M6 noxref_12 A1 Y VDD pmos_rvt L=2e-08 W=8.1e-08 nfin=3
M7 VDD A2 noxref_12 VDD pmos_rvt L=2e-08 W=8.1e-08 nfin=3
M8 noxref_13 B2 VDD VDD pmos_rvt L=2e-08 W=8.1e-08 nfin=3
M9 Y B1 noxref_13 VDD pmos_rvt L=2e-08 W=8.1e-08 nfin=3
M10 noxref_14 C1 Y VDD pmos_rvt L=2e-08 W=8.1e-08 nfin=3
M11 VDD C2 noxref_14 VDD pmos_rvt L=2e-08 W=8.1e-08 nfin=3
.ENDS

.SUBCKT OAI22x1_ASAP7_75t_R A1 A2 B1 B2 VDD VSS Y
M0 VSS B2 noxref_7 VSS nmos_rvt L=2e-08 W=8.1e-08 nfin=3
M1 noxref_7 B1 VSS VSS nmos_rvt L=2e-08 W=8.1e-08 nfin=3
M2 noxref_7 B1 VSS VSS nmos_rvt L=2e-08 W=8.1e-08 nfin=3
M3 VSS B2 noxref_7 VSS nmos_rvt L=2e-08 W=8.1e-08 nfin=3
M4 Y A2 noxref_7 VSS nmos_rvt L=2e-08 W=8.1e-08 nfin=3
M5 noxref_7 A1 Y VSS nmos_rvt L=2e-08 W=8.1e-08 nfin=3
M6 noxref_7 A1 Y VSS nmos_rvt L=2e-08 W=8.1e-08 nfin=3
M7 Y A2 noxref_7 VSS nmos_rvt L=2e-08 W=8.1e-08 nfin=3
M8 Y B2 noxref_9 VDD pmos_rvt L=2e-08 W=8.1e-08 nfin=3
M9 noxref_9 B1 VDD VDD pmos_rvt L=2e-08 W=8.1e-08 nfin=3
M10 noxref_10 B1 VDD VDD pmos_rvt L=2e-08 W=8.1e-08 nfin=3
M11 Y B2 noxref_10 VDD pmos_rvt L=2e-08 W=8.1e-08 nfin=3
M12 Y A2 noxref_11 VDD pmos_rvt L=2e-08 W=8.1e-08 nfin=3
M13 noxref_11 A1 VDD VDD pmos_rvt L=2e-08 W=8.1e-08 nfin=3
M14 noxref_12 A1 VDD VDD pmos_rvt L=2e-08 W=8.1e-08 nfin=3
M15 Y A2 noxref_12 VDD pmos_rvt L=2e-08 W=8.1e-08 nfin=3
.ENDS

.SUBCKT OAI22xp33_ASAP7_75t_R A1 A2 B1 B2 VDD VSS Y
M0 Y A1 noxref_8 VSS nmos_rvt L=2e-08 W=5.4e-08 nfin=2
M1 noxref_8 A2 Y VSS nmos_rvt L=2e-08 W=5.4e-08 nfin=2
M2 VSS B2 noxref_8 VSS nmos_rvt L=2e-08 W=5.4e-08 nfin=2
M3 noxref_8 B1 VSS VSS nmos_rvt L=2e-08 W=5.4e-08 nfin=2
M4 noxref_9 A1 VDD VDD pmos_rvt L=2e-08 W=5.4e-08 nfin=2
M5 Y A2 noxref_9 VDD pmos_rvt L=2e-08 W=5.4e-08 nfin=2
M6 noxref_10 B2 Y VDD pmos_rvt L=2e-08 W=5.4e-08 nfin=2
M7 VDD B1 noxref_10 VDD pmos_rvt L=2e-08 W=5.4e-08 nfin=2
.ENDS

.SUBCKT OAI22xp5_ASAP7_75t_R A1 A2 B1 B2 VDD VSS Y
M0 Y A1 noxref_8 VSS nmos_rvt L=2e-08 W=8.1e-08 nfin=3
M1 noxref_8 A2 Y VSS nmos_rvt L=2e-08 W=8.1e-08 nfin=3
M2 VSS B2 noxref_8 VSS nmos_rvt L=2e-08 W=8.1e-08 nfin=3
M3 noxref_8 B1 VSS VSS nmos_rvt L=2e-08 W=8.1e-08 nfin=3
M4 noxref_9 A1 VDD VDD pmos_rvt L=2e-08 W=8.1e-08 nfin=3
M5 Y A2 noxref_9 VDD pmos_rvt L=2e-08 W=8.1e-08 nfin=3
M6 noxref_10 B2 Y VDD pmos_rvt L=2e-08 W=8.1e-08 nfin=3
M7 VDD B1 noxref_10 VDD pmos_rvt L=2e-08 W=8.1e-08 nfin=3
.ENDS

.SUBCKT OAI311xp33_ASAP7_75t_R A1 A2 A3 B1 C1 VDD VSS Y
M0 noxref_8 A3 VSS VSS nmos_rvt L=2e-08 W=8.1e-08 nfin=3
M1 VSS A2 noxref_8 VSS nmos_rvt L=2e-08 W=8.1e-08 nfin=3
M2 noxref_8 A1 VSS VSS nmos_rvt L=2e-08 W=8.1e-08 nfin=3
M3 noxref_10 B1 noxref_8 VSS nmos_rvt L=2e-08 W=8.1e-08 nfin=3
M4 Y C1 noxref_10 VSS nmos_rvt L=2e-08 W=8.1e-08 nfin=3
M5 noxref_11 A3 VDD VDD pmos_rvt L=2e-08 W=8.1e-08 nfin=3
M6 noxref_12 A2 noxref_11 VDD pmos_rvt L=2e-08 W=8.1e-08 nfin=3
M7 Y A1 noxref_12 VDD pmos_rvt L=2e-08 W=8.1e-08 nfin=3
M8 VDD B1 Y VDD pmos_rvt L=2e-08 W=5.4e-08 nfin=2
M9 Y C1 VDD VDD pmos_rvt L=2e-08 W=5.4e-08 nfin=2
.ENDS

.SUBCKT OAI31xp33_ASAP7_75t_R A1 A2 A3 B VDD VSS Y
M0 noxref_7 A3 VSS VSS nmos_rvt L=2e-08 W=5.4e-08 nfin=2
M1 VSS A2 noxref_7 VSS nmos_rvt L=2e-08 W=5.4e-08 nfin=2
M2 noxref_7 A1 VSS VSS nmos_rvt L=2e-08 W=5.4e-08 nfin=2
M3 Y B noxref_7 VSS nmos_rvt L=2e-08 W=5.4e-08 nfin=2
M4 noxref_9 A3 VDD VDD pmos_rvt L=2e-08 W=8.1e-08 nfin=3
M5 noxref_10 A2 noxref_9 VDD pmos_rvt L=2e-08 W=8.1e-08 nfin=3
M6 Y A1 noxref_10 VDD pmos_rvt L=2e-08 W=8.1e-08 nfin=3
M7 VDD B Y VDD pmos_rvt L=2e-08 W=5.4e-08 nfin=2
.ENDS

.SUBCKT OAI31xp67_ASAP7_75t_R A1 A2 A3 B VDD VSS Y
M0 VSS A3 noxref_7 VSS nmos_rvt L=2e-08 W=8.1e-08 nfin=3
M1 VSS A3 noxref_7 VSS nmos_rvt L=2e-08 W=8.1e-08 nfin=3
M2 Y B noxref_7 VSS nmos_rvt L=2e-08 W=8.1e-08 nfin=3
M3 Y B noxref_7 VSS nmos_rvt L=2e-08 W=8.1e-08 nfin=3
M4 noxref_7 A2 VSS VSS nmos_rvt L=2e-08 W=8.1e-08 nfin=3
M5 noxref_7 A2 VSS VSS nmos_rvt L=2e-08 W=8.1e-08 nfin=3
M6 noxref_7 A1 VSS VSS nmos_rvt L=2e-08 W=8.1e-08 nfin=3
M7 noxref_7 A1 VSS VSS nmos_rvt L=2e-08 W=8.1e-08 nfin=3
M8 noxref_8 A3 VDD VDD pmos_rvt L=2e-08 W=8.1e-08 nfin=3
M9 noxref_8 A3 VDD VDD pmos_rvt L=2e-08 W=8.1e-08 nfin=3
M10 Y B VDD VDD pmos_rvt L=2e-08 W=5.4e-08 nfin=2
M11 noxref_8 A2 noxref_10 VDD pmos_rvt L=2e-08 W=8.1e-08 nfin=3
M12 noxref_8 A2 noxref_10 VDD pmos_rvt L=2e-08 W=8.1e-08 nfin=3
M13 Y A1 noxref_10 VDD pmos_rvt L=2e-08 W=8.1e-08 nfin=3
M14 Y A1 noxref_10 VDD pmos_rvt L=2e-08 W=8.1e-08 nfin=3
.ENDS

.SUBCKT OAI321xp33_ASAP7_75t_R A1 A2 A3 B1 B2 C VDD VSS Y
M0 noxref_9 A3 VSS VSS nmos_rvt L=2e-08 W=8.1e-08 nfin=3
M1 VSS A2 noxref_9 VSS nmos_rvt L=2e-08 W=8.1e-08 nfin=3
M2 noxref_9 A1 VSS VSS nmos_rvt L=2e-08 W=8.1e-08 nfin=3
M3 noxref_10 C noxref_9 VSS nmos_rvt L=2e-08 W=8.1e-08 nfin=3
M4 Y B1 noxref_10 VSS nmos_rvt L=2e-08 W=8.1e-08 nfin=3
M5 noxref_10 B2 Y VSS nmos_rvt L=2e-08 W=8.1e-08 nfin=3
M6 noxref_12 A3 VDD VDD pmos_rvt L=2e-08 W=8.1e-08 nfin=3
M7 noxref_13 A2 noxref_12 VDD pmos_rvt L=2e-08 W=8.1e-08 nfin=3
M8 Y A1 noxref_13 VDD pmos_rvt L=2e-08 W=8.1e-08 nfin=3
M9 VDD C Y VDD pmos_rvt L=2e-08 W=5.4e-08 nfin=2
M10 noxref_14 B1 VDD VDD pmos_rvt L=2e-08 W=5.4e-08 nfin=2
M11 Y B2 noxref_14 VDD pmos_rvt L=2e-08 W=5.4e-08 nfin=2
.ENDS

.SUBCKT OAI322xp33_ASAP7_75t_R A1 A2 A3 B1 B2 C1 C2 VDD VSS Y
M0 VSS B2 noxref_10 VSS nmos_rvt L=2e-08 W=8.1e-08 nfin=3
M1 noxref_10 B1 VSS VSS nmos_rvt L=2e-08 W=8.1e-08 nfin=3
M2 noxref_11 A1 noxref_10 VSS nmos_rvt L=2e-08 W=8.1e-08 nfin=3
M3 noxref_10 A2 noxref_11 VSS nmos_rvt L=2e-08 W=8.1e-08 nfin=3
M4 noxref_11 A3 noxref_10 VSS nmos_rvt L=2e-08 W=8.1e-08 nfin=3
M5 Y C2 noxref_11 VSS nmos_rvt L=2e-08 W=8.1e-08 nfin=3
M6 noxref_11 C1 Y VSS nmos_rvt L=2e-08 W=8.1e-08 nfin=3
M7 noxref_13 B2 VDD VDD pmos_rvt L=2e-08 W=5.4e-08 nfin=2
M8 Y B1 noxref_13 VDD pmos_rvt L=2e-08 W=5.4e-08 nfin=2
M9 noxref_14 A1 Y VDD pmos_rvt L=2e-08 W=8.1e-08 nfin=3
M10 noxref_15 A2 noxref_14 VDD pmos_rvt L=2e-08 W=8.1e-08 nfin=3
M11 VDD A3 noxref_15 VDD pmos_rvt L=2e-08 W=8.1e-08 nfin=3
M12 noxref_16 C2 VDD VDD pmos_rvt L=2e-08 W=5.4e-08 nfin=2
M13 Y C1 noxref_16 VDD pmos_rvt L=2e-08 W=5.4e-08 nfin=2
.ENDS

.SUBCKT OAI32xp33_ASAP7_75t_R A1 A2 A3 B1 B2 VDD VSS Y
M0 noxref_8 A1 VSS VSS nmos_rvt L=2e-08 W=5.4e-08 nfin=2
M1 VSS A2 noxref_8 VSS nmos_rvt L=2e-08 W=5.4e-08 nfin=2
M2 noxref_8 A3 VSS VSS nmos_rvt L=2e-08 W=5.4e-08 nfin=2
M3 Y B1 noxref_8 VSS nmos_rvt L=2e-08 W=5.4e-08 nfin=2
M4 noxref_8 B2 Y VSS nmos_rvt L=2e-08 W=5.4e-08 nfin=2
M5 noxref_10 A1 Y VDD pmos_rvt L=2e-08 W=8.1e-08 nfin=3
M6 noxref_11 A2 noxref_10 VDD pmos_rvt L=2e-08 W=8.1e-08 nfin=3
M7 VDD A3 noxref_11 VDD pmos_rvt L=2e-08 W=8.1e-08 nfin=3
M8 noxref_12 B1 VDD VDD pmos_rvt L=2e-08 W=5.4e-08 nfin=2
M9 Y B2 noxref_12 VDD pmos_rvt L=2e-08 W=5.4e-08 nfin=2
.ENDS

.SUBCKT OAI331xp33_ASAP7_75t_R A1 A2 A3 B1 B2 B3 C1 VDD VSS Y
M0 noxref_10 A3 VSS VSS nmos_rvt L=2e-08 W=8.1e-08 nfin=3
M1 VSS A2 noxref_10 VSS nmos_rvt L=2e-08 W=8.1e-08 nfin=3
M2 noxref_10 A1 VSS VSS nmos_rvt L=2e-08 W=8.1e-08 nfin=3
M3 noxref_11 B1 noxref_10 VSS nmos_rvt L=2e-08 W=8.1e-08 nfin=3
M4 noxref_10 B2 noxref_11 VSS nmos_rvt L=2e-08 W=8.1e-08 nfin=3
M5 noxref_11 B3 noxref_10 VSS nmos_rvt L=2e-08 W=8.1e-08 nfin=3
M6 Y C1 noxref_11 VSS nmos_rvt L=2e-08 W=8.1e-08 nfin=3
M7 noxref_13 A3 VDD VDD pmos_rvt L=2e-08 W=8.1e-08 nfin=3
M8 noxref_14 A2 noxref_13 VDD pmos_rvt L=2e-08 W=8.1e-08 nfin=3
M9 Y A1 noxref_14 VDD pmos_rvt L=2e-08 W=8.1e-08 nfin=3
M10 noxref_15 B1 Y VDD pmos_rvt L=2e-08 W=8.1e-08 nfin=3
M11 noxref_16 B2 noxref_15 VDD pmos_rvt L=2e-08 W=8.1e-08 nfin=3
M12 VDD B3 noxref_16 VDD pmos_rvt L=2e-08 W=8.1e-08 nfin=3
M13 Y C1 VDD VDD pmos_rvt L=2e-08 W=8.1e-08 nfin=3
.ENDS

.SUBCKT OAI332xp33_ASAP7_75t_R A1 A2 A3 B1 B2 B3 C1 C2 VDD VSS Y
M0 noxref_11 A3 VSS VSS nmos_rvt L=2e-08 W=8.1e-08 nfin=3
M1 VSS A2 noxref_11 VSS nmos_rvt L=2e-08 W=8.1e-08 nfin=3
M2 noxref_11 A1 VSS VSS nmos_rvt L=2e-08 W=8.1e-08 nfin=3
M3 noxref_12 B1 noxref_11 VSS nmos_rvt L=2e-08 W=8.1e-08 nfin=3
M4 noxref_11 B2 noxref_12 VSS nmos_rvt L=2e-08 W=8.1e-08 nfin=3
M5 noxref_12 B3 noxref_11 VSS nmos_rvt L=2e-08 W=8.1e-08 nfin=3
M6 Y C2 noxref_12 VSS nmos_rvt L=2e-08 W=8.1e-08 nfin=3
M7 noxref_12 C1 Y VSS nmos_rvt L=2e-08 W=8.1e-08 nfin=3
M8 noxref_14 A3 VDD VDD pmos_rvt L=2e-08 W=8.1e-08 nfin=3
M9 noxref_15 A2 noxref_14 VDD pmos_rvt L=2e-08 W=8.1e-08 nfin=3
M10 Y A1 noxref_15 VDD pmos_rvt L=2e-08 W=8.1e-08 nfin=3
M11 noxref_16 B1 Y VDD pmos_rvt L=2e-08 W=8.1e-08 nfin=3
M12 noxref_17 B2 noxref_16 VDD pmos_rvt L=2e-08 W=8.1e-08 nfin=3
M13 VDD B3 noxref_17 VDD pmos_rvt L=2e-08 W=8.1e-08 nfin=3
M14 noxref_18 C2 VDD VDD pmos_rvt L=2e-08 W=8.1e-08 nfin=3
M15 Y C1 noxref_18 VDD pmos_rvt L=2e-08 W=8.1e-08 nfin=3
.ENDS

.SUBCKT OAI333xp33_ASAP7_75t_R A1 A2 A3 B1 B2 B3 C1 C2 C3 VDD VSS Y
M0 noxref_12 C3 VSS VSS nmos_rvt L=2e-08 W=8.1e-08 nfin=3
M1 VSS C2 noxref_12 VSS nmos_rvt L=2e-08 W=8.1e-08 nfin=3
M2 noxref_12 C1 VSS VSS nmos_rvt L=2e-08 W=8.1e-08 nfin=3
M3 noxref_13 B1 noxref_12 VSS nmos_rvt L=2e-08 W=8.1e-08 nfin=3
M4 noxref_12 B2 noxref_13 VSS nmos_rvt L=2e-08 W=8.1e-08 nfin=3
M5 noxref_13 B3 noxref_12 VSS nmos_rvt L=2e-08 W=8.1e-08 nfin=3
M6 Y A3 noxref_13 VSS nmos_rvt L=2e-08 W=8.1e-08 nfin=3
M7 noxref_13 A2 Y VSS nmos_rvt L=2e-08 W=8.1e-08 nfin=3
M8 Y A1 noxref_13 VSS nmos_rvt L=2e-08 W=8.1e-08 nfin=3
M9 noxref_15 C3 VDD VDD pmos_rvt L=2e-08 W=8.1e-08 nfin=3
M10 noxref_16 C2 noxref_15 VDD pmos_rvt L=2e-08 W=8.1e-08 nfin=3
M11 Y C1 noxref_16 VDD pmos_rvt L=2e-08 W=8.1e-08 nfin=3
M12 noxref_17 B1 Y VDD pmos_rvt L=2e-08 W=8.1e-08 nfin=3
M13 noxref_18 B2 noxref_17 VDD pmos_rvt L=2e-08 W=8.1e-08 nfin=3
M14 VDD B3 noxref_18 VDD pmos_rvt L=2e-08 W=8.1e-08 nfin=3
M15 noxref_19 A3 VDD VDD pmos_rvt L=2e-08 W=8.1e-08 nfin=3
M16 noxref_20 A2 noxref_19 VDD pmos_rvt L=2e-08 W=8.1e-08 nfin=3
M17 Y A1 noxref_20 VDD pmos_rvt L=2e-08 W=8.1e-08 nfin=3
.ENDS

.SUBCKT OAI33xp33_ASAP7_75t_R A1 A2 A3 B1 B2 B3 VDD VSS Y
M0 noxref_9 A1 VSS VSS nmos_rvt L=2e-08 W=5.4e-08 nfin=2
M1 VSS A2 noxref_9 VSS nmos_rvt L=2e-08 W=5.4e-08 nfin=2
M2 noxref_9 A3 VSS VSS nmos_rvt L=2e-08 W=5.4e-08 nfin=2
M3 Y B1 noxref_9 VSS nmos_rvt L=2e-08 W=5.4e-08 nfin=2
M4 noxref_9 B2 Y VSS nmos_rvt L=2e-08 W=5.4e-08 nfin=2
M5 Y B3 noxref_9 VSS nmos_rvt L=2e-08 W=5.4e-08 nfin=2
M6 noxref_11 A1 VDD VDD pmos_rvt L=2e-08 W=8.1e-08 nfin=3
M7 noxref_12 A2 noxref_11 VDD pmos_rvt L=2e-08 W=8.1e-08 nfin=3
M8 Y A3 noxref_12 VDD pmos_rvt L=2e-08 W=8.1e-08 nfin=3
M9 noxref_13 B1 Y VDD pmos_rvt L=2e-08 W=8.1e-08 nfin=3
M10 noxref_14 B2 noxref_13 VDD pmos_rvt L=2e-08 W=8.1e-08 nfin=3
M11 VDD B3 noxref_14 VDD pmos_rvt L=2e-08 W=8.1e-08 nfin=3
.ENDS

.SUBCKT OR2x2_ASAP7_75t_R A B VDD VSS Y
M0 N_M0_d B VSS VSS nmos_rvt L=2e-08 W=5.4e-08 nfin=2
M1 VSS A N_M0_d VSS nmos_rvt L=2e-08 W=5.4e-08 nfin=2
M2 Y N_M0_d VSS VSS nmos_rvt L=2e-08 W=8.1e-08 nfin=3
M3 Y N_M0_d VSS VSS nmos_rvt L=2e-08 W=8.1e-08 nfin=3
M4 N_M4_d B N_M0_d VDD pmos_rvt L=2e-08 W=8.1e-08 nfin=3
M5 VDD A N_M4_d VDD pmos_rvt L=2e-08 W=8.1e-08 nfin=3
M6 Y N_M0_d VDD VDD pmos_rvt L=2e-08 W=8.1e-08 nfin=3
M7 Y N_M0_d VDD VDD pmos_rvt L=2e-08 W=8.1e-08 nfin=3
.ENDS

.SUBCKT OR2x4_ASAP7_75t_R A B VDD VSS Y
M0 N_M0_d B VSS VSS nmos_rvt L=2e-08 W=5.4e-08 nfin=2
M1 VSS A N_M0_d VSS nmos_rvt L=2e-08 W=5.4e-08 nfin=2
M2 Y N_M0_d VSS VSS nmos_rvt L=2e-08 W=8.1e-08 nfin=3
M3 Y N_M0_d VSS VSS nmos_rvt L=2e-08 W=8.1e-08 nfin=3
M4 Y N_M0_d VSS VSS nmos_rvt L=2e-08 W=8.1e-08 nfin=3
M5 Y N_M0_d VSS VSS nmos_rvt L=2e-08 W=8.1e-08 nfin=3
M6 N_M6_d B N_M0_d VDD pmos_rvt L=2e-08 W=8.1e-08 nfin=3
M7 VDD A N_M6_d VDD pmos_rvt L=2e-08 W=8.1e-08 nfin=3
M8 Y N_M0_d VDD VDD pmos_rvt L=2e-08 W=8.1e-08 nfin=3
M9 Y N_M0_d VDD VDD pmos_rvt L=2e-08 W=8.1e-08 nfin=3
M10 Y N_M0_d VDD VDD pmos_rvt L=2e-08 W=8.1e-08 nfin=3
M11 Y N_M0_d VDD VDD pmos_rvt L=2e-08 W=8.1e-08 nfin=3
.ENDS

.SUBCKT OR2x6_ASAP7_75t_R A B VDD VSS Y
M0 N_M0_d B VSS VSS nmos_rvt L=2e-08 W=5.4e-08 nfin=2
M1 VSS A N_M0_d VSS nmos_rvt L=2e-08 W=5.4e-08 nfin=2
M2 VSS A N_M0_d VSS nmos_rvt L=2e-08 W=5.4e-08 nfin=2
M3 N_M0_d B VSS VSS nmos_rvt L=2e-08 W=5.4e-08 nfin=2
M4 Y N_M0_d VSS VSS nmos_rvt L=2e-08 W=8.1e-08 nfin=3
M5 Y N_M0_d VSS VSS nmos_rvt L=2e-08 W=8.1e-08 nfin=3
M6 Y N_M0_d VSS VSS nmos_rvt L=2e-08 W=8.1e-08 nfin=3
M7 Y N_M0_d VSS VSS nmos_rvt L=2e-08 W=8.1e-08 nfin=3
M8 Y N_M0_d VSS VSS nmos_rvt L=2e-08 W=8.1e-08 nfin=3
M9 Y N_M0_d VSS VSS nmos_rvt L=2e-08 W=8.1e-08 nfin=3
M10 VDD B N_M10_s VDD pmos_rvt L=2e-08 W=8.1e-08 nfin=3
M11 N_M10_s A N_M0_d VDD pmos_rvt L=2e-08 W=8.1e-08 nfin=3
M12 N_M12_d A N_M0_d VDD pmos_rvt L=2e-08 W=8.1e-08 nfin=3
M13 VDD B N_M12_d VDD pmos_rvt L=2e-08 W=8.1e-08 nfin=3
M14 Y N_M0_d VDD VDD pmos_rvt L=2e-08 W=8.1e-08 nfin=3
M15 Y N_M0_d VDD VDD pmos_rvt L=2e-08 W=8.1e-08 nfin=3
M16 Y N_M0_d VDD VDD pmos_rvt L=2e-08 W=8.1e-08 nfin=3
M17 Y N_M0_d VDD VDD pmos_rvt L=2e-08 W=8.1e-08 nfin=3
M18 Y N_M0_d VDD VDD pmos_rvt L=2e-08 W=8.1e-08 nfin=3
M19 Y N_M0_d VDD VDD pmos_rvt L=2e-08 W=8.1e-08 nfin=3
.ENDS

.SUBCKT OR3x1_ASAP7_75t_R A B C VDD VSS Y
M0 VSS A N_M0_s VSS nmos_rvt L=2e-08 W=8.1e-08 nfin=3
M1 N_M0_s B VSS VSS nmos_rvt L=2e-08 W=8.1e-08 nfin=3
M2 VSS C N_M0_s VSS nmos_rvt L=2e-08 W=8.1e-08 nfin=3
M3 Y N_M0_s VSS VSS nmos_rvt L=2e-08 W=8.1e-08 nfin=3
M4 N_M4_d A N_M0_s VDD pmos_rvt L=2e-08 W=8.1e-08 nfin=3
M5 N_M5_d B N_M4_d VDD pmos_rvt L=2e-08 W=8.1e-08 nfin=3
M6 VDD C N_M5_d VDD pmos_rvt L=2e-08 W=8.1e-08 nfin=3
M7 Y N_M0_s VDD VDD pmos_rvt L=2e-08 W=8.1e-08 nfin=3
.ENDS

.SUBCKT OR3x2_ASAP7_75t_R A B C VDD VSS Y
M0 VSS A N_M0_s VSS nmos_rvt L=2e-08 W=8.1e-08 nfin=3
M1 N_M0_s B VSS VSS nmos_rvt L=2e-08 W=8.1e-08 nfin=3
M2 VSS C N_M0_s VSS nmos_rvt L=2e-08 W=8.1e-08 nfin=3
M3 Y N_M0_s VSS VSS nmos_rvt L=2e-08 W=8.1e-08 nfin=3
M4 Y N_M0_s VSS VSS nmos_rvt L=2e-08 W=8.1e-08 nfin=3
M5 N_M5_d A N_M0_s VDD pmos_rvt L=2e-08 W=8.1e-08 nfin=3
M6 N_M6_d B N_M5_d VDD pmos_rvt L=2e-08 W=8.1e-08 nfin=3
M7 VDD C N_M6_d VDD pmos_rvt L=2e-08 W=8.1e-08 nfin=3
M8 Y N_M0_s VDD VDD pmos_rvt L=2e-08 W=8.1e-08 nfin=3
M9 Y N_M0_s VDD VDD pmos_rvt L=2e-08 W=8.1e-08 nfin=3
.ENDS

.SUBCKT OR3x4_ASAP7_75t_R A B C VDD VSS Y
M0 VSS A N_M0_s VSS nmos_rvt L=2e-08 W=8.1e-08 nfin=3
M1 N_M0_s B VSS VSS nmos_rvt L=2e-08 W=8.1e-08 nfin=3
M2 VSS C N_M0_s VSS nmos_rvt L=2e-08 W=8.1e-08 nfin=3
M3 Y N_M0_s VSS VSS nmos_rvt L=2e-08 W=8.1e-08 nfin=3
M4 Y N_M0_s VSS VSS nmos_rvt L=2e-08 W=8.1e-08 nfin=3
M5 Y N_M0_s VSS VSS nmos_rvt L=2e-08 W=8.1e-08 nfin=3
M6 Y N_M0_s VSS VSS nmos_rvt L=2e-08 W=8.1e-08 nfin=3
M7 N_M7_d A N_M0_s VDD pmos_rvt L=2e-08 W=8.1e-08 nfin=3
M8 N_M8_d B N_M7_d VDD pmos_rvt L=2e-08 W=8.1e-08 nfin=3
M9 VDD C N_M8_d VDD pmos_rvt L=2e-08 W=8.1e-08 nfin=3
M10 Y N_M0_s VDD VDD pmos_rvt L=2e-08 W=8.1e-08 nfin=3
M11 Y N_M0_s VDD VDD pmos_rvt L=2e-08 W=8.1e-08 nfin=3
M12 Y N_M0_s VDD VDD pmos_rvt L=2e-08 W=8.1e-08 nfin=3
M13 Y N_M0_s VDD VDD pmos_rvt L=2e-08 W=8.1e-08 nfin=3
.ENDS

.SUBCKT OR4x1_ASAP7_75t_R A B C D VDD VSS Y
M0 VSS N_M0_g Y VSS nmos_rvt L=2e-08 W=8.1e-08 nfin=3
M1 N_M0_g D VSS VSS nmos_rvt L=2e-08 W=8.1e-08 nfin=3
M2 VSS C N_M0_g VSS nmos_rvt L=2e-08 W=8.1e-08 nfin=3
M3 N_M0_g B VSS VSS nmos_rvt L=2e-08 W=8.1e-08 nfin=3
M4 VSS A N_M0_g VSS nmos_rvt L=2e-08 W=8.1e-08 nfin=3
M5 VDD N_M0_g Y VDD pmos_rvt L=2e-08 W=8.1e-08 nfin=3
M6 N_M6_d D VDD VDD pmos_rvt L=2e-08 W=8.1e-08 nfin=3
M7 N_M7_d C N_M6_d VDD pmos_rvt L=2e-08 W=8.1e-08 nfin=3
M8 N_M8_d B N_M7_d VDD pmos_rvt L=2e-08 W=8.1e-08 nfin=3
M9 N_M0_g A N_M8_d VDD pmos_rvt L=2e-08 W=8.1e-08 nfin=3
.ENDS

.SUBCKT OR4x2_ASAP7_75t_R A B C D VDD VSS Y
M0 Y N_M0_g VSS VSS nmos_rvt L=2e-08 W=8.1e-08 nfin=3
M1 Y N_M0_g VSS VSS nmos_rvt L=2e-08 W=8.1e-08 nfin=3
M2 N_M0_g D VSS VSS nmos_rvt L=2e-08 W=8.1e-08 nfin=3
M3 VSS C N_M0_g VSS nmos_rvt L=2e-08 W=8.1e-08 nfin=3
M4 N_M0_g B VSS VSS nmos_rvt L=2e-08 W=8.1e-08 nfin=3
M5 VSS A N_M0_g VSS nmos_rvt L=2e-08 W=8.1e-08 nfin=3
M6 Y N_M0_g VDD VDD pmos_rvt L=2e-08 W=8.1e-08 nfin=3
M7 Y N_M0_g VDD VDD pmos_rvt L=2e-08 W=8.1e-08 nfin=3
M8 N_M8_d D VDD VDD pmos_rvt L=2e-08 W=8.1e-08 nfin=3
M9 N_M9_d C N_M8_d VDD pmos_rvt L=2e-08 W=8.1e-08 nfin=3
M10 N_M10_d B N_M9_d VDD pmos_rvt L=2e-08 W=8.1e-08 nfin=3
M11 N_M0_g A N_M10_d VDD pmos_rvt L=2e-08 W=8.1e-08 nfin=3
.ENDS

.SUBCKT OR5x1_ASAP7_75t_R A B C D E VDD VSS Y
M0 VSS A N_M0_s VSS nmos_rvt L=2e-08 W=5.4e-08 nfin=2
M1 N_M0_s B VSS VSS nmos_rvt L=2e-08 W=5.4e-08 nfin=2
M2 VSS C N_M0_s VSS nmos_rvt L=2e-08 W=5.4e-08 nfin=2
M3 N_M0_s D VSS VSS nmos_rvt L=2e-08 W=5.4e-08 nfin=2
M4 VSS E N_M0_s VSS nmos_rvt L=2e-08 W=5.4e-08 nfin=2
M5 Y N_M0_s VSS VSS nmos_rvt L=2e-08 W=8.1e-08 nfin=3
M6 N_M6_d A N_M0_s VDD pmos_rvt L=2e-08 W=8.1e-08 nfin=3
M7 N_M7_d B N_M6_d VDD pmos_rvt L=2e-08 W=8.1e-08 nfin=3
M8 N_M8_d C N_M7_d VDD pmos_rvt L=2e-08 W=8.1e-08 nfin=3
M9 N_M9_d D N_M8_d VDD pmos_rvt L=2e-08 W=8.1e-08 nfin=3
M10 VDD E N_M9_d VDD pmos_rvt L=2e-08 W=8.1e-08 nfin=3
M11 Y N_M0_s VDD VDD pmos_rvt L=2e-08 W=8.1e-08 nfin=3
.ENDS

.SUBCKT OR5x2_ASAP7_75t_R A B C D E VDD VSS Y
M0 VSS A N_M0_s VSS nmos_rvt L=2e-08 W=5.4e-08 nfin=2
M1 N_M0_s B VSS VSS nmos_rvt L=2e-08 W=5.4e-08 nfin=2
M2 VSS C N_M0_s VSS nmos_rvt L=2e-08 W=5.4e-08 nfin=2
M3 N_M0_s D VSS VSS nmos_rvt L=2e-08 W=5.4e-08 nfin=2
M4 VSS E N_M0_s VSS nmos_rvt L=2e-08 W=5.4e-08 nfin=2
M5 Y N_M0_s VSS VSS nmos_rvt L=2e-08 W=8.1e-08 nfin=3
M6 Y N_M0_s VSS VSS nmos_rvt L=2e-08 W=8.1e-08 nfin=3
M7 N_M7_d A N_M0_s VDD pmos_rvt L=2e-08 W=8.1e-08 nfin=3
M8 N_M8_d B N_M7_d VDD pmos_rvt L=2e-08 W=8.1e-08 nfin=3
M9 N_M9_d C N_M8_d VDD pmos_rvt L=2e-08 W=8.1e-08 nfin=3
M10 N_M10_d D N_M9_d VDD pmos_rvt L=2e-08 W=8.1e-08 nfin=3
M11 VDD E N_M10_d VDD pmos_rvt L=2e-08 W=8.1e-08 nfin=3
M12 Y N_M0_s VDD VDD pmos_rvt L=2e-08 W=8.1e-08 nfin=3
M13 Y N_M0_s VDD VDD pmos_rvt L=2e-08 W=8.1e-08 nfin=3
.ENDS

.SUBCKT SDFHx1_ASAP7_75t_R CLK D QN SE SI VDD VSS
M0 VSS CLK N_M0_s VSS nmos_rvt L=2e-08 W=5.4e-08 nfin=2
M1 N_M1_d N_M0_s VSS VSS nmos_rvt L=2e-08 W=5.4e-08 nfin=2
M2 VSS SE noxref_15 VSS nmos_rvt L=2e-08 W=8.1e-08 nfin=3
M3 noxref_21 N_M3_g VSS VSS nmos_rvt L=2e-08 W=8.1e-08 nfin=3
M4 noxref_17 D noxref_21 VSS nmos_rvt L=2e-08 W=8.1e-08 nfin=3
M5 noxref_15 SI noxref_17 VSS nmos_rvt L=2e-08 W=8.1e-08 nfin=3
M6 N_M6_d N_M0_s noxref_17 VSS nmos_rvt L=2e-08 W=8.1e-08 nfin=3
M7 N_M7_d N_M1_d N_M6_d VSS nmos_rvt L=2e-08 W=2.7e-08 nfin=1
M8 VSS N_M8_g N_M7_d VSS nmos_rvt L=2e-08 W=2.7e-08 nfin=1
M9 N_M8_g N_M6_d VSS VSS nmos_rvt L=2e-08 W=2.7e-08 nfin=1
M10 N_M10_d N_M1_d N_M8_g VSS nmos_rvt L=2e-08 W=2.7e-08 nfin=1
M11 N_M11_d N_M0_s N_M10_d VSS nmos_rvt L=2e-08 W=2.7e-08 nfin=1
M12 VSS N_M12_g N_M11_d VSS nmos_rvt L=2e-08 W=2.7e-08 nfin=1
M13 N_M12_g N_M10_d VSS VSS nmos_rvt L=2e-08 W=2.7e-08 nfin=1
M14 VSS SE N_M3_g VSS nmos_rvt L=2e-08 W=2.7e-08 nfin=1
M15 QN N_M10_d VSS VSS nmos_rvt L=2e-08 W=8.1e-08 nfin=3
M16 VDD CLK N_M0_s VDD pmos_rvt L=2e-08 W=5.4e-08 nfin=2
M17 N_M1_d N_M0_s VDD VDD pmos_rvt L=2e-08 W=5.4e-08 nfin=2
M18 N_M18_d SE N_M18_s VDD pmos_rvt L=2e-08 W=8.1e-08 nfin=3
M19 VDD N_M3_g N_M18_d VDD pmos_rvt L=2e-08 W=8.1e-08 nfin=3
M20 N_M18_d D VDD VDD pmos_rvt L=2e-08 W=8.1e-08 nfin=3
M21 N_M18_s SI N_M18_d VDD pmos_rvt L=2e-08 W=8.1e-08 nfin=3
M22 N_M6_d N_M1_d N_M18_s VDD pmos_rvt L=2e-08 W=8.1e-08 nfin=3
M23 N_M23_d N_M0_s N_M6_d VDD pmos_rvt L=2e-08 W=2.7e-08 nfin=1
M24 VDD N_M8_g N_M23_d VDD pmos_rvt L=2e-08 W=2.7e-08 nfin=1
M25 N_M8_g N_M6_d VDD VDD pmos_rvt L=2e-08 W=2.7e-08 nfin=1
M26 N_M10_d N_M0_s N_M8_g VDD pmos_rvt L=2e-08 W=2.7e-08 nfin=1
M27 N_M27_d N_M1_d N_M10_d VDD pmos_rvt L=2e-08 W=2.7e-08 nfin=1
M28 VDD N_M12_g N_M27_d VDD pmos_rvt L=2e-08 W=2.7e-08 nfin=1
M29 N_M12_g N_M10_d VDD VDD pmos_rvt L=2e-08 W=2.7e-08 nfin=1
M30 VDD SE N_M3_g VDD pmos_rvt L=2e-08 W=2.7e-08 nfin=1
M31 QN N_M10_d VDD VDD pmos_rvt L=2e-08 W=8.1e-08 nfin=3
.ENDS

.SUBCKT SDFHx2_ASAP7_75t_R CLK D QN SE SI VDD VSS
M0 VSS CLK N_M0_s VSS nmos_rvt L=2e-08 W=5.4e-08 nfin=2
M1 N_M1_d N_M0_s VSS VSS nmos_rvt L=2e-08 W=5.4e-08 nfin=2
M2 VSS SE noxref_15 VSS nmos_rvt L=2e-08 W=8.1e-08 nfin=3
M3 noxref_21 N_M3_g VSS VSS nmos_rvt L=2e-08 W=8.1e-08 nfin=3
M4 noxref_17 D noxref_21 VSS nmos_rvt L=2e-08 W=8.1e-08 nfin=3
M5 noxref_15 SI noxref_17 VSS nmos_rvt L=2e-08 W=8.1e-08 nfin=3
M6 N_M6_d N_M0_s noxref_17 VSS nmos_rvt L=2e-08 W=8.1e-08 nfin=3
M7 N_M7_d N_M1_d N_M6_d VSS nmos_rvt L=2e-08 W=2.7e-08 nfin=1
M8 VSS N_M8_g N_M7_d VSS nmos_rvt L=2e-08 W=2.7e-08 nfin=1
M9 N_M8_g N_M6_d VSS VSS nmos_rvt L=2e-08 W=2.7e-08 nfin=1
M10 N_M10_d N_M1_d N_M8_g VSS nmos_rvt L=2e-08 W=2.7e-08 nfin=1
M11 N_M11_d N_M0_s N_M10_d VSS nmos_rvt L=2e-08 W=2.7e-08 nfin=1
M12 VSS N_M12_g N_M11_d VSS nmos_rvt L=2e-08 W=2.7e-08 nfin=1
M13 N_M12_g N_M10_d VSS VSS nmos_rvt L=2e-08 W=2.7e-08 nfin=1
M14 VSS SE N_M3_g VSS nmos_rvt L=2e-08 W=2.7e-08 nfin=1
M15 QN N_M10_d VSS VSS nmos_rvt L=2e-08 W=8.1e-08 nfin=3
M16 QN N_M10_d VSS VSS nmos_rvt L=2e-08 W=8.1e-08 nfin=3
M17 VDD CLK N_M0_s VDD pmos_rvt L=2e-08 W=5.4e-08 nfin=2
M18 N_M1_d N_M0_s VDD VDD pmos_rvt L=2e-08 W=5.4e-08 nfin=2
M19 N_M19_d SE N_M19_s VDD pmos_rvt L=2e-08 W=8.1e-08 nfin=3
M20 VDD N_M3_g N_M19_d VDD pmos_rvt L=2e-08 W=8.1e-08 nfin=3
M21 N_M19_d D VDD VDD pmos_rvt L=2e-08 W=8.1e-08 nfin=3
M22 N_M19_s SI N_M19_d VDD pmos_rvt L=2e-08 W=8.1e-08 nfin=3
M23 N_M6_d N_M1_d N_M19_s VDD pmos_rvt L=2e-08 W=8.1e-08 nfin=3
M24 N_M24_d N_M0_s N_M6_d VDD pmos_rvt L=2e-08 W=2.7e-08 nfin=1
M25 VDD N_M8_g N_M24_d VDD pmos_rvt L=2e-08 W=2.7e-08 nfin=1
M26 N_M8_g N_M6_d VDD VDD pmos_rvt L=2e-08 W=2.7e-08 nfin=1
M27 N_M10_d N_M0_s N_M8_g VDD pmos_rvt L=2e-08 W=2.7e-08 nfin=1
M28 N_M28_d N_M1_d N_M10_d VDD pmos_rvt L=2e-08 W=2.7e-08 nfin=1
M29 VDD N_M12_g N_M28_d VDD pmos_rvt L=2e-08 W=2.7e-08 nfin=1
M30 N_M12_g N_M10_d VDD VDD pmos_rvt L=2e-08 W=2.7e-08 nfin=1
M31 VDD SE N_M3_g VDD pmos_rvt L=2e-08 W=2.7e-08 nfin=1
M32 QN N_M10_d VDD VDD pmos_rvt L=2e-08 W=8.1e-08 nfin=3
M33 QN N_M10_d VDD VDD pmos_rvt L=2e-08 W=8.1e-08 nfin=3
.ENDS

.SUBCKT SDFHx3_ASAP7_75t_R CLK D QN SE SI VDD VSS
M0 VSS CLK N_M0_s VSS nmos_rvt L=2e-08 W=5.4e-08 nfin=2
M1 N_M1_d N_M0_s VSS VSS nmos_rvt L=2e-08 W=5.4e-08 nfin=2
M2 VSS SE noxref_15 VSS nmos_rvt L=2e-08 W=8.1e-08 nfin=3
M3 noxref_21 N_M3_g VSS VSS nmos_rvt L=2e-08 W=8.1e-08 nfin=3
M4 noxref_17 D noxref_21 VSS nmos_rvt L=2e-08 W=8.1e-08 nfin=3
M5 noxref_15 SI noxref_17 VSS nmos_rvt L=2e-08 W=8.1e-08 nfin=3
M6 N_M6_d N_M0_s noxref_17 VSS nmos_rvt L=2e-08 W=8.1e-08 nfin=3
M7 N_M7_d N_M1_d N_M6_d VSS nmos_rvt L=2e-08 W=2.7e-08 nfin=1
M8 VSS N_M8_g N_M7_d VSS nmos_rvt L=2e-08 W=2.7e-08 nfin=1
M9 N_M8_g N_M6_d VSS VSS nmos_rvt L=2e-08 W=2.7e-08 nfin=1
M10 N_M10_d N_M1_d N_M8_g VSS nmos_rvt L=2e-08 W=2.7e-08 nfin=1
M11 N_M11_d N_M0_s N_M10_d VSS nmos_rvt L=2e-08 W=2.7e-08 nfin=1
M12 VSS N_M12_g N_M11_d VSS nmos_rvt L=2e-08 W=2.7e-08 nfin=1
M13 N_M12_g N_M10_d VSS VSS nmos_rvt L=2e-08 W=2.7e-08 nfin=1
M14 VSS SE N_M3_g VSS nmos_rvt L=2e-08 W=2.7e-08 nfin=1
M15 QN N_M10_d VSS VSS nmos_rvt L=2e-08 W=8.1e-08 nfin=3
M16 QN N_M10_d VSS VSS nmos_rvt L=2e-08 W=8.1e-08 nfin=3
M17 QN N_M10_d VSS VSS nmos_rvt L=2e-08 W=8.1e-08 nfin=3
M18 VDD CLK N_M0_s VDD pmos_rvt L=2e-08 W=5.4e-08 nfin=2
M19 N_M1_d N_M0_s VDD VDD pmos_rvt L=2e-08 W=5.4e-08 nfin=2
M20 N_M20_d SE N_M20_s VDD pmos_rvt L=2e-08 W=8.1e-08 nfin=3
M21 VDD N_M3_g N_M20_d VDD pmos_rvt L=2e-08 W=8.1e-08 nfin=3
M22 N_M20_d D VDD VDD pmos_rvt L=2e-08 W=8.1e-08 nfin=3
M23 N_M20_s SI N_M20_d VDD pmos_rvt L=2e-08 W=8.1e-08 nfin=3
M24 N_M6_d N_M1_d N_M20_s VDD pmos_rvt L=2e-08 W=8.1e-08 nfin=3
M25 N_M25_d N_M0_s N_M6_d VDD pmos_rvt L=2e-08 W=2.7e-08 nfin=1
M26 VDD N_M8_g N_M25_d VDD pmos_rvt L=2e-08 W=2.7e-08 nfin=1
M27 N_M8_g N_M6_d VDD VDD pmos_rvt L=2e-08 W=2.7e-08 nfin=1
M28 N_M10_d N_M0_s N_M8_g VDD pmos_rvt L=2e-08 W=2.7e-08 nfin=1
M29 N_M29_d N_M1_d N_M10_d VDD pmos_rvt L=2e-08 W=2.7e-08 nfin=1
M30 VDD N_M12_g N_M29_d VDD pmos_rvt L=2e-08 W=2.7e-08 nfin=1
M31 N_M12_g N_M10_d VDD VDD pmos_rvt L=2e-08 W=2.7e-08 nfin=1
M32 VDD SE N_M3_g VDD pmos_rvt L=2e-08 W=2.7e-08 nfin=1
M33 QN N_M10_d VDD VDD pmos_rvt L=2e-08 W=8.1e-08 nfin=3
M34 QN N_M10_d VDD VDD pmos_rvt L=2e-08 W=8.1e-08 nfin=3
M35 QN N_M10_d VDD VDD pmos_rvt L=2e-08 W=8.1e-08 nfin=3
.ENDS

.SUBCKT SDFHx4_ASAP7_75t_R CLK D QN SE SI VDD VSS
M0 VSS CLK N_M0_s VSS nmos_rvt L=2e-08 W=8.1e-08 nfin=3
M1 N_M1_d N_M0_s VSS VSS nmos_rvt L=2e-08 W=8.1e-08 nfin=3
M2 N_M2_d SE VSS VSS nmos_rvt L=2e-08 W=8.1e-08 nfin=3
M3 noxref_20 D noxref_14 VSS nmos_rvt L=2e-08 W=8.1e-08 nfin=3
M4 VSS N_M2_d noxref_20 VSS nmos_rvt L=2e-08 W=8.1e-08 nfin=3
M5 noxref_21 SE VSS VSS nmos_rvt L=2e-08 W=8.1e-08 nfin=3
M6 noxref_14 SI noxref_21 VSS nmos_rvt L=2e-08 W=8.1e-08 nfin=3
M7 N_M7_d N_M0_s noxref_14 VSS nmos_rvt L=2e-08 W=8.1e-08 nfin=3
M8 N_M8_d N_M1_d N_M7_d VSS nmos_rvt L=2e-08 W=8.1e-08 nfin=3
M9 VSS N_M9_g N_M8_d VSS nmos_rvt L=2e-08 W=8.1e-08 nfin=3
M10 N_M9_g N_M7_d VSS VSS nmos_rvt L=2e-08 W=8.1e-08 nfin=3
M11 N_M11_d N_M1_d N_M9_g VSS nmos_rvt L=2e-08 W=8.1e-08 nfin=3
M12 N_M12_d N_M0_s N_M11_d VSS nmos_rvt L=2e-08 W=8.1e-08 nfin=3
M13 VSS N_M13_g N_M12_d VSS nmos_rvt L=2e-08 W=8.1e-08 nfin=3
M14 N_M13_g N_M11_d VSS VSS nmos_rvt L=2e-08 W=8.1e-08 nfin=3
M15 QN N_M11_d VSS VSS nmos_rvt L=2e-08 W=8.1e-08 nfin=3
M16 QN N_M11_d VSS VSS nmos_rvt L=2e-08 W=8.1e-08 nfin=3
M17 QN N_M11_d VSS VSS nmos_rvt L=2e-08 W=8.1e-08 nfin=3
M18 QN N_M11_d VSS VSS nmos_rvt L=2e-08 W=8.1e-08 nfin=3
M19 VDD CLK N_M0_s VDD pmos_rvt L=2e-08 W=8.1e-08 nfin=3
M20 N_M1_d N_M0_s VDD VDD pmos_rvt L=2e-08 W=8.1e-08 nfin=3
M21 N_M2_d SE VDD VDD pmos_rvt L=2e-08 W=8.1e-08 nfin=3
M22 VDD D N_M22_s VDD pmos_rvt L=2e-08 W=8.1e-08 nfin=3
M23 N_M22_s N_M2_d VDD VDD pmos_rvt L=2e-08 W=8.1e-08 nfin=3
M24 N_M24_d SE N_M22_s VDD pmos_rvt L=2e-08 W=8.1e-08 nfin=3
M25 N_M22_s SI N_M24_d VDD pmos_rvt L=2e-08 W=8.1e-08 nfin=3
M26 N_M7_d N_M1_d N_M24_d VDD pmos_rvt L=2e-08 W=8.1e-08 nfin=3
M27 N_M27_d N_M0_s N_M7_d VDD pmos_rvt L=2e-08 W=8.1e-08 nfin=3
M28 VDD N_M9_g N_M27_d VDD pmos_rvt L=2e-08 W=8.1e-08 nfin=3
M29 N_M9_g N_M7_d VDD VDD pmos_rvt L=2e-08 W=8.1e-08 nfin=3
M30 N_M11_d N_M0_s N_M9_g VDD pmos_rvt L=2e-08 W=8.1e-08 nfin=3
M31 N_M31_d N_M1_d N_M11_d VDD pmos_rvt L=2e-08 W=8.1e-08 nfin=3
M32 VDD N_M13_g N_M31_d VDD pmos_rvt L=2e-08 W=8.1e-08 nfin=3
M33 N_M13_g N_M11_d VDD VDD pmos_rvt L=2e-08 W=8.1e-08 nfin=3
M34 QN N_M11_d VDD VDD pmos_rvt L=2e-08 W=8.1e-08 nfin=3
M35 QN N_M11_d VDD VDD pmos_rvt L=2e-08 W=8.1e-08 nfin=3
M36 QN N_M11_d VDD VDD pmos_rvt L=2e-08 W=8.1e-08 nfin=3
M37 QN N_M11_d VDD VDD pmos_rvt L=2e-08 W=8.1e-08 nfin=3
.ENDS

.SUBCKT SDFLx1_ASAP7_75t_R CLK D QN SE SI VDD VSS
M0 VSS CLK N_M0_s VSS nmos_rvt L=2e-08 W=5.4e-08 nfin=2
M1 N_M1_d N_M0_s VSS VSS nmos_rvt L=2e-08 W=5.4e-08 nfin=2
M2 VSS SE noxref_15 VSS nmos_rvt L=2e-08 W=8.1e-08 nfin=3
M3 noxref_21 N_M3_g VSS VSS nmos_rvt L=2e-08 W=8.1e-08 nfin=3
M4 noxref_17 D noxref_21 VSS nmos_rvt L=2e-08 W=8.1e-08 nfin=3
M5 noxref_15 SI noxref_17 VSS nmos_rvt L=2e-08 W=8.1e-08 nfin=3
M6 N_M6_d N_M1_d noxref_17 VSS nmos_rvt L=2e-08 W=8.1e-08 nfin=3
M7 N_M7_d N_M0_s N_M6_d VSS nmos_rvt L=2e-08 W=2.7e-08 nfin=1
M8 VSS N_M8_g N_M7_d VSS nmos_rvt L=2e-08 W=2.7e-08 nfin=1
M9 N_M8_g N_M6_d VSS VSS nmos_rvt L=2e-08 W=2.7e-08 nfin=1
M10 N_M10_d N_M0_s N_M8_g VSS nmos_rvt L=2e-08 W=2.7e-08 nfin=1
M11 N_M11_d N_M1_d N_M10_d VSS nmos_rvt L=2e-08 W=2.7e-08 nfin=1
M12 VSS N_M12_g N_M11_d VSS nmos_rvt L=2e-08 W=2.7e-08 nfin=1
M13 N_M12_g N_M10_d VSS VSS nmos_rvt L=2e-08 W=2.7e-08 nfin=1
M14 VSS SE N_M3_g VSS nmos_rvt L=2e-08 W=8.1e-08 nfin=3
M15 QN N_M10_d VSS VSS nmos_rvt L=2e-08 W=8.1e-08 nfin=3
M16 VDD CLK N_M0_s VDD pmos_rvt L=2e-08 W=5.4e-08 nfin=2
M17 N_M1_d N_M0_s VDD VDD pmos_rvt L=2e-08 W=5.4e-08 nfin=2
M18 N_M18_d SE N_M18_s VDD pmos_rvt L=2e-08 W=8.1e-08 nfin=3
M19 VDD N_M3_g N_M18_d VDD pmos_rvt L=2e-08 W=8.1e-08 nfin=3
M20 N_M18_d D VDD VDD pmos_rvt L=2e-08 W=8.1e-08 nfin=3
M21 N_M18_s SI N_M18_d VDD pmos_rvt L=2e-08 W=8.1e-08 nfin=3
M22 N_M6_d N_M0_s N_M18_s VDD pmos_rvt L=2e-08 W=8.1e-08 nfin=3
M23 N_M23_d N_M1_d N_M6_d VDD pmos_rvt L=2e-08 W=2.7e-08 nfin=1
M24 VDD N_M8_g N_M23_d VDD pmos_rvt L=2e-08 W=2.7e-08 nfin=1
M25 N_M8_g N_M6_d VDD VDD pmos_rvt L=2e-08 W=2.7e-08 nfin=1
M26 N_M10_d N_M1_d N_M8_g VDD pmos_rvt L=2e-08 W=2.7e-08 nfin=1
M27 N_M27_d N_M0_s N_M10_d VDD pmos_rvt L=2e-08 W=2.7e-08 nfin=1
M28 VDD N_M12_g N_M27_d VDD pmos_rvt L=2e-08 W=2.7e-08 nfin=1
M29 N_M12_g N_M10_d VDD VDD pmos_rvt L=2e-08 W=2.7e-08 nfin=1
M30 VDD SE N_M3_g VDD pmos_rvt L=2e-08 W=8.1e-08 nfin=3
M31 QN N_M10_d VDD VDD pmos_rvt L=2e-08 W=8.1e-08 nfin=3
.ENDS

.SUBCKT SDFLx2_ASAP7_75t_R CLK D QN SE SI VDD VSS
M0 VSS CLK N_M0_s VSS nmos_rvt L=2e-08 W=5.4e-08 nfin=2
M1 N_M1_d N_M0_s VSS VSS nmos_rvt L=2e-08 W=5.4e-08 nfin=2
M2 VSS SE noxref_15 VSS nmos_rvt L=2e-08 W=8.1e-08 nfin=3
M3 noxref_21 N_M3_g VSS VSS nmos_rvt L=2e-08 W=8.1e-08 nfin=3
M4 noxref_17 D noxref_21 VSS nmos_rvt L=2e-08 W=8.1e-08 nfin=3
M5 noxref_15 SI noxref_17 VSS nmos_rvt L=2e-08 W=8.1e-08 nfin=3
M6 N_M6_d N_M1_d noxref_17 VSS nmos_rvt L=2e-08 W=8.1e-08 nfin=3
M7 N_M7_d N_M0_s N_M6_d VSS nmos_rvt L=2e-08 W=2.7e-08 nfin=1
M8 VSS N_M8_g N_M7_d VSS nmos_rvt L=2e-08 W=2.7e-08 nfin=1
M9 N_M8_g N_M6_d VSS VSS nmos_rvt L=2e-08 W=2.7e-08 nfin=1
M10 N_M10_d N_M0_s N_M8_g VSS nmos_rvt L=2e-08 W=2.7e-08 nfin=1
M11 N_M11_d N_M1_d N_M10_d VSS nmos_rvt L=2e-08 W=2.7e-08 nfin=1
M12 VSS N_M12_g N_M11_d VSS nmos_rvt L=2e-08 W=2.7e-08 nfin=1
M13 N_M12_g N_M10_d VSS VSS nmos_rvt L=2e-08 W=2.7e-08 nfin=1
M14 VSS SE N_M3_g VSS nmos_rvt L=2e-08 W=8.1e-08 nfin=3
M15 QN N_M10_d VSS VSS nmos_rvt L=2e-08 W=8.1e-08 nfin=3
M16 QN N_M10_d VSS VSS nmos_rvt L=2e-08 W=8.1e-08 nfin=3
M17 VDD CLK N_M0_s VDD pmos_rvt L=2e-08 W=5.4e-08 nfin=2
M18 N_M1_d N_M0_s VDD VDD pmos_rvt L=2e-08 W=5.4e-08 nfin=2
M19 N_M19_d SE N_M19_s VDD pmos_rvt L=2e-08 W=8.1e-08 nfin=3
M20 VDD N_M3_g N_M19_d VDD pmos_rvt L=2e-08 W=8.1e-08 nfin=3
M21 N_M19_d D VDD VDD pmos_rvt L=2e-08 W=8.1e-08 nfin=3
M22 N_M19_s SI N_M19_d VDD pmos_rvt L=2e-08 W=8.1e-08 nfin=3
M23 N_M6_d N_M0_s N_M19_s VDD pmos_rvt L=2e-08 W=8.1e-08 nfin=3
M24 N_M24_d N_M1_d N_M6_d VDD pmos_rvt L=2e-08 W=2.7e-08 nfin=1
M25 VDD N_M8_g N_M24_d VDD pmos_rvt L=2e-08 W=2.7e-08 nfin=1
M26 N_M8_g N_M6_d VDD VDD pmos_rvt L=2e-08 W=2.7e-08 nfin=1
M27 N_M10_d N_M1_d N_M8_g VDD pmos_rvt L=2e-08 W=2.7e-08 nfin=1
M28 N_M28_d N_M0_s N_M10_d VDD pmos_rvt L=2e-08 W=2.7e-08 nfin=1
M29 VDD N_M12_g N_M28_d VDD pmos_rvt L=2e-08 W=2.7e-08 nfin=1
M30 N_M12_g N_M10_d VDD VDD pmos_rvt L=2e-08 W=2.7e-08 nfin=1
M31 VDD SE N_M3_g VDD pmos_rvt L=2e-08 W=8.1e-08 nfin=3
M32 QN N_M10_d VDD VDD pmos_rvt L=2e-08 W=8.1e-08 nfin=3
M33 QN N_M10_d VDD VDD pmos_rvt L=2e-08 W=8.1e-08 nfin=3
.ENDS

.SUBCKT SDFLx3_ASAP7_75t_R CLK D QN SE SI VDD VSS
M0 VSS CLK N_M0_s VSS nmos_rvt L=2e-08 W=5.4e-08 nfin=2
M1 N_M1_d N_M0_s VSS VSS nmos_rvt L=2e-08 W=5.4e-08 nfin=2
M2 VSS SE noxref_15 VSS nmos_rvt L=2e-08 W=8.1e-08 nfin=3
M3 noxref_21 N_M3_g VSS VSS nmos_rvt L=2e-08 W=8.1e-08 nfin=3
M4 noxref_17 D noxref_21 VSS nmos_rvt L=2e-08 W=8.1e-08 nfin=3
M5 noxref_15 SI noxref_17 VSS nmos_rvt L=2e-08 W=8.1e-08 nfin=3
M6 N_M6_d N_M1_d noxref_17 VSS nmos_rvt L=2e-08 W=8.1e-08 nfin=3
M7 N_M7_d N_M0_s N_M6_d VSS nmos_rvt L=2e-08 W=2.7e-08 nfin=1
M8 VSS N_M8_g N_M7_d VSS nmos_rvt L=2e-08 W=2.7e-08 nfin=1
M9 N_M8_g N_M6_d VSS VSS nmos_rvt L=2e-08 W=2.7e-08 nfin=1
M10 N_M10_d N_M0_s N_M8_g VSS nmos_rvt L=2e-08 W=2.7e-08 nfin=1
M11 N_M11_d N_M1_d N_M10_d VSS nmos_rvt L=2e-08 W=2.7e-08 nfin=1
M12 VSS N_M12_g N_M11_d VSS nmos_rvt L=2e-08 W=2.7e-08 nfin=1
M13 N_M12_g N_M10_d VSS VSS nmos_rvt L=2e-08 W=2.7e-08 nfin=1
M14 VSS SE N_M3_g VSS nmos_rvt L=2e-08 W=8.1e-08 nfin=3
M15 QN N_M10_d VSS VSS nmos_rvt L=2e-08 W=8.1e-08 nfin=3
M16 QN N_M10_d VSS VSS nmos_rvt L=2e-08 W=8.1e-08 nfin=3
M17 QN N_M10_d VSS VSS nmos_rvt L=2e-08 W=8.1e-08 nfin=3
M18 VDD CLK N_M0_s VDD pmos_rvt L=2e-08 W=5.4e-08 nfin=2
M19 N_M1_d N_M0_s VDD VDD pmos_rvt L=2e-08 W=5.4e-08 nfin=2
M20 N_M20_d SE N_M20_s VDD pmos_rvt L=2e-08 W=8.1e-08 nfin=3
M21 VDD N_M3_g N_M20_d VDD pmos_rvt L=2e-08 W=8.1e-08 nfin=3
M22 N_M20_d D VDD VDD pmos_rvt L=2e-08 W=8.1e-08 nfin=3
M23 N_M20_s SI N_M20_d VDD pmos_rvt L=2e-08 W=8.1e-08 nfin=3
M24 N_M6_d N_M0_s N_M20_s VDD pmos_rvt L=2e-08 W=8.1e-08 nfin=3
M25 N_M25_d N_M1_d N_M6_d VDD pmos_rvt L=2e-08 W=2.7e-08 nfin=1
M26 VDD N_M8_g N_M25_d VDD pmos_rvt L=2e-08 W=2.7e-08 nfin=1
M27 N_M8_g N_M6_d VDD VDD pmos_rvt L=2e-08 W=2.7e-08 nfin=1
M28 N_M10_d N_M1_d N_M8_g VDD pmos_rvt L=2e-08 W=2.7e-08 nfin=1
M29 N_M29_d N_M0_s N_M10_d VDD pmos_rvt L=2e-08 W=2.7e-08 nfin=1
M30 VDD N_M12_g N_M29_d VDD pmos_rvt L=2e-08 W=2.7e-08 nfin=1
M31 N_M12_g N_M10_d VDD VDD pmos_rvt L=2e-08 W=2.7e-08 nfin=1
M32 VDD SE N_M3_g VDD pmos_rvt L=2e-08 W=8.1e-08 nfin=3
M33 QN N_M10_d VDD VDD pmos_rvt L=2e-08 W=8.1e-08 nfin=3
M34 QN N_M10_d VDD VDD pmos_rvt L=2e-08 W=8.1e-08 nfin=3
M35 QN N_M10_d VDD VDD pmos_rvt L=2e-08 W=8.1e-08 nfin=3
.ENDS

.SUBCKT SDFLx4_ASAP7_75t_R CLK D QN SE SI VDD VSS
M0 VSS CLK N_M0_s VSS nmos_rvt L=2e-08 W=8.1e-08 nfin=3
M1 N_M1_d N_M0_s VSS VSS nmos_rvt L=2e-08 W=8.1e-08 nfin=3
M2 N_M2_d SE VSS VSS nmos_rvt L=2e-08 W=8.1e-08 nfin=3
M3 noxref_21 D noxref_14 VSS nmos_rvt L=2e-08 W=8.1e-08 nfin=3
M4 VSS N_M2_d noxref_21 VSS nmos_rvt L=2e-08 W=8.1e-08 nfin=3
M5 noxref_22 SE VSS VSS nmos_rvt L=2e-08 W=8.1e-08 nfin=3
M6 noxref_14 SI noxref_22 VSS nmos_rvt L=2e-08 W=8.1e-08 nfin=3
M7 N_M7_d N_M1_d noxref_14 VSS nmos_rvt L=2e-08 W=8.1e-08 nfin=3
M8 N_M8_d N_M0_s N_M7_d VSS nmos_rvt L=2e-08 W=8.1e-08 nfin=3
M9 VSS N_M9_g N_M8_d VSS nmos_rvt L=2e-08 W=8.1e-08 nfin=3
M10 N_M9_g N_M7_d VSS VSS nmos_rvt L=2e-08 W=8.1e-08 nfin=3
M11 N_M11_d N_M0_s N_M9_g VSS nmos_rvt L=2e-08 W=8.1e-08 nfin=3
M12 N_M12_d N_M1_d N_M11_d VSS nmos_rvt L=2e-08 W=8.1e-08 nfin=3
M13 VSS N_M13_g N_M12_d VSS nmos_rvt L=2e-08 W=8.1e-08 nfin=3
M14 N_M13_g N_M11_d VSS VSS nmos_rvt L=2e-08 W=8.1e-08 nfin=3
M15 QN N_M11_d VSS VSS nmos_rvt L=2e-08 W=8.1e-08 nfin=3
M16 QN N_M11_d VSS VSS nmos_rvt L=2e-08 W=8.1e-08 nfin=3
M17 QN N_M11_d VSS VSS nmos_rvt L=2e-08 W=8.1e-08 nfin=3
M18 QN N_M11_d VSS VSS nmos_rvt L=2e-08 W=8.1e-08 nfin=3
M19 VDD CLK N_M0_s VDD pmos_rvt L=2e-08 W=8.1e-08 nfin=3
M20 N_M1_d N_M0_s VDD VDD pmos_rvt L=2e-08 W=8.1e-08 nfin=3
M21 N_M2_d SE VDD VDD pmos_rvt L=2e-08 W=8.1e-08 nfin=3
M22 VDD D N_M22_s VDD pmos_rvt L=2e-08 W=8.1e-08 nfin=3
M23 N_M22_s N_M2_d VDD VDD pmos_rvt L=2e-08 W=8.1e-08 nfin=3
M24 N_M24_d SE N_M22_s VDD pmos_rvt L=2e-08 W=8.1e-08 nfin=3
M25 N_M22_s SI N_M24_d VDD pmos_rvt L=2e-08 W=8.1e-08 nfin=3
M26 N_M7_d N_M0_s N_M24_d VDD pmos_rvt L=2e-08 W=8.1e-08 nfin=3
M27 N_M27_d N_M1_d N_M7_d VDD pmos_rvt L=2e-08 W=8.1e-08 nfin=3
M28 VDD N_M9_g N_M27_d VDD pmos_rvt L=2e-08 W=8.1e-08 nfin=3
M29 N_M9_g N_M7_d VDD VDD pmos_rvt L=2e-08 W=8.1e-08 nfin=3
M30 N_M11_d N_M1_d N_M9_g VDD pmos_rvt L=2e-08 W=8.1e-08 nfin=3
M31 N_M31_d N_M0_s N_M11_d VDD pmos_rvt L=2e-08 W=8.1e-08 nfin=3
M32 VDD N_M13_g N_M31_d VDD pmos_rvt L=2e-08 W=8.1e-08 nfin=3
M33 N_M13_g N_M11_d VDD VDD pmos_rvt L=2e-08 W=8.1e-08 nfin=3
M34 QN N_M11_d VDD VDD pmos_rvt L=2e-08 W=8.1e-08 nfin=3
M35 QN N_M11_d VDD VDD pmos_rvt L=2e-08 W=8.1e-08 nfin=3
M36 QN N_M11_d VDD VDD pmos_rvt L=2e-08 W=8.1e-08 nfin=3
M37 QN N_M11_d VDD VDD pmos_rvt L=2e-08 W=8.1e-08 nfin=3
.ENDS

* --------------------------------------------------------------------------
* TBUFx1_ASAP7_75t_R below is a port of TBUF_X1 from the Nangate Open
* Cell Library. Its licence requires the notice and statement reproduced here.
*
* Copyright (C) 2004-2010, Nangate Inc.  All rights reserved.
*
* Nangate Open Cell Library License, Version 1.0. February 20, 2008
*
* Permission is hereby granted, free of charge, to any person or
* organization obtaining a copy of the Open Cell Library and accompanying
* documentation (the "Library") covered by this license to use, reproduce,
* display, distribute, execute, and transmit the Library, and to prepare
* derivative works of the Library, and to permit third-parties to whom the
* Library is furnished to do so, all subject to the following:
*
* The copyright notices in the Library and this entire statement, including
* the above license grant, this restriction and the following disclaimer,
* must be included in all copies of the Library, in whole or in part, and
* all derivative works of the Library, unless such copies or derivative
* works are solely in the form of machine-executable object code generated
* by a source language processor. The library has been generated using a
* non-optimized open PDK and is not suited for any commercial purpose.
* Measuring or benchmarking the Library against any other library or
* standard cell set is prohibited. Any meaningful library benchmarking must
* be done in collaboration with Nangate or other providers of optimized and
* production-ready PDKs.
*
* THE LIBRARY IS PROVIDED "AS IS", WITHOUT WARRANTY OF ANY KIND, EXPRESS OR
* IMPLIED, INCLUDING BUT NOT LIMITED TO THE WARRANTIES OF MERCHANTABILITY,
* FITNESS FOR A PARTICULAR PURPOSE, TITLE AND NON-INFRINGEMENT. IN NO EVENT
* SHALL THE COPYRIGHT HOLDERS OR ANYONE DISTRIBUTING THE LIBRARY BE LIABLE
* FOR ANY DAMAGES OR OTHER LIABILITY, WHETHER IN CONTRACT, TORT OR
* OTHERWISE, ARISING FROM, OUT OF OR IN CONNECTION WITH THE LIBRARY OR THE
* USE OR OTHER DEALINGS IN THE LIBRARY.
* --------------------------------------------------------------------------
.SUBCKT TBUFx1_ASAP7_75t_R A EN VDD VSS Z
M0 VSS N_1_M0_g Z VSS NMOS_RVT L=2e-08 W=8.1e-08 NFIN=3
M3 VSS A N_1_M0_g VSS NMOS_RVT L=2e-08 W=5.4e-08 NFIN=2
M4 VSS EN N_1_M0_g VSS NMOS_RVT L=2e-08 W=5.4e-08 NFIN=2
M5 VSS EN N_3_M5_s VSS NMOS_RVT L=2e-08 W=2.7e-08 NFIN=1
M5@2 VSS EN N_3_M5_s VSS NMOS_RVT L=2e-08 W=2.7e-08 NFIN=1
M2 VSS N_3_M5_s N_5_M2_s VSS NMOS_RVT L=2e-08 W=5.4e-08 NFIN=2
M1 N_5_M2_s A N_2_M1_s VSS NMOS_RVT L=2e-08 W=5.4e-08 NFIN=2
M6 VDD N_2_M1_s Z VDD PMOS_RVT L=2e-08 W=8.1e-08 NFIN=3
M9 VDD A N_4_M9_s VDD PMOS_RVT L=2e-08 W=5.4e-08 NFIN=2
M10 N_4_M9_s EN N_1_M0_g VDD PMOS_RVT L=2e-08 W=5.4e-08 NFIN=2
M11 VDD EN N_3_M5_s VDD PMOS_RVT L=2e-08 W=5.4e-08 NFIN=2
M8 N_2_M1_s N_3_M5_s VDD VDD PMOS_RVT L=2e-08 W=5.4e-08 NFIN=2
M7 VDD A N_2_M1_s VDD PMOS_RVT L=2e-08 W=5.4e-08 NFIN=2
.ENDS

.SUBCKT TIEHIx1_ASAP7_75t_R H VDD VSS
M0 VSS H N_M0_s VSS nmos_rvt L=2e-08 W=2.7e-08 nfin=1
M1 H N_M0_s VDD VDD pmos_rvt L=2e-08 W=5.4e-08 nfin=2
.ENDS

.SUBCKT TIELOx1_ASAP7_75t_R L VDD VSS
M0 L N_M0_g VSS VSS nmos_rvt L=2e-08 W=5.4e-08 nfin=2
M1 VDD L N_M0_g VDD pmos_rvt L=2e-08 W=2.7e-08 nfin=1
.ENDS

.SUBCKT XNOR2x1_ASAP7_75t_R A B VDD VSS Y
M0 N_M0_d B VSS VSS nmos_rvt L=2e-08 W=8.1e-08 nfin=3
M1 N_M1_d A N_M0_d VSS nmos_rvt L=2e-08 W=8.1e-08 nfin=3
M2 VSS A noxref_6 VSS nmos_rvt L=2e-08 W=8.1e-08 nfin=3
M3 noxref_6 B VSS VSS nmos_rvt L=2e-08 W=8.1e-08 nfin=3
M4 Y N_M1_d noxref_6 VSS nmos_rvt L=2e-08 W=8.1e-08 nfin=3
M5 Y N_M1_d noxref_6 VSS nmos_rvt L=2e-08 W=8.1e-08 nfin=3
M6 noxref_6 B VSS VSS nmos_rvt L=2e-08 W=8.1e-08 nfin=3
M7 VSS A noxref_6 VSS nmos_rvt L=2e-08 W=8.1e-08 nfin=3
M8 N_M1_d B VDD VDD pmos_rvt L=2e-08 W=8.1e-08 nfin=3
M9 VDD A N_M1_d VDD pmos_rvt L=2e-08 W=8.1e-08 nfin=3
M10 Y A noxref_9 VDD pmos_rvt L=2e-08 W=8.1e-08 nfin=3
M11 noxref_9 B VDD VDD pmos_rvt L=2e-08 W=8.1e-08 nfin=3
M12 Y N_M1_d VDD VDD pmos_rvt L=2e-08 W=8.1e-08 nfin=3
M13 Y N_M1_d VDD VDD pmos_rvt L=2e-08 W=8.1e-08 nfin=3
M14 noxref_10 B VDD VDD pmos_rvt L=2e-08 W=8.1e-08 nfin=3
M15 Y A noxref_10 VDD pmos_rvt L=2e-08 W=8.1e-08 nfin=3
.ENDS

.SUBCKT XNOR2x2_ASAP7_75t_R A B VDD VSS Y
M0 VSS N_M0_g N_M0_s VSS nmos_rvt L=2e-08 W=8.1e-08 nfin=3
M1 noxref_9 A VSS VSS nmos_rvt L=2e-08 W=8.1e-08 nfin=3
M2 N_M0_s B noxref_9 VSS nmos_rvt L=2e-08 W=8.1e-08 nfin=3
M3 N_M0_g B VSS VSS nmos_rvt L=2e-08 W=5.4e-08 nfin=2
M4 VSS A N_M0_g VSS nmos_rvt L=2e-08 W=5.4e-08 nfin=2
M5 Y N_M0_s VSS VSS nmos_rvt L=2e-08 W=8.1e-08 nfin=3
M6 Y N_M0_s VSS VSS nmos_rvt L=2e-08 W=8.1e-08 nfin=3
M7 noxref_7 N_M0_g N_M0_s VDD pmos_rvt L=2e-08 W=8.1e-08 nfin=3
M8 VDD A noxref_7 VDD pmos_rvt L=2e-08 W=8.1e-08 nfin=3
M9 noxref_7 B VDD VDD pmos_rvt L=2e-08 W=8.1e-08 nfin=3
M10 N_M10_d B N_M0_g VDD pmos_rvt L=2e-08 W=8.1e-08 nfin=3
M11 VDD A N_M10_d VDD pmos_rvt L=2e-08 W=8.1e-08 nfin=3
M12 Y N_M0_s VDD VDD pmos_rvt L=2e-08 W=8.1e-08 nfin=3
M13 Y N_M0_s VDD VDD pmos_rvt L=2e-08 W=8.1e-08 nfin=3
.ENDS

.SUBCKT XNOR2xp5_ASAP7_75t_R A B VDD VSS Y
M0 N_M0_d A VSS VSS nmos_rvt L=2e-08 W=8.1e-08 nfin=3
M1 N_M1_d B N_M0_d VSS nmos_rvt L=2e-08 W=8.1e-08 nfin=3
M2 VSS B noxref_6 VSS nmos_rvt L=2e-08 W=8.1e-08 nfin=3
M3 noxref_6 A VSS VSS nmos_rvt L=2e-08 W=8.1e-08 nfin=3
M4 Y N_M1_d noxref_6 VSS nmos_rvt L=2e-08 W=8.1e-08 nfin=3
M5 N_M1_d A VDD VDD pmos_rvt L=2e-08 W=5.4e-08 nfin=2
M6 VDD B N_M1_d VDD pmos_rvt L=2e-08 W=5.4e-08 nfin=2
M7 noxref_9 B Y VDD pmos_rvt L=2e-08 W=8.1e-08 nfin=3
M8 VDD A noxref_9 VDD pmos_rvt L=2e-08 W=8.1e-08 nfin=3
M9 Y N_M1_d VDD VDD pmos_rvt L=2e-08 W=8.1e-08 nfin=3
.ENDS

.SUBCKT XOR2x1_ASAP7_75t_R A B VDD VSS Y
M0 N_M0_d A VSS VSS nmos_rvt L=2e-08 W=8.1e-08 nfin=3
M1 VSS B N_M0_d VSS nmos_rvt L=2e-08 W=8.1e-08 nfin=3
M2 Y B noxref_8 VSS nmos_rvt L=2e-08 W=8.1e-08 nfin=3
M3 noxref_8 A VSS VSS nmos_rvt L=2e-08 W=8.1e-08 nfin=3
M4 Y N_M0_d VSS VSS nmos_rvt L=2e-08 W=8.1e-08 nfin=3
M5 Y N_M0_d VSS VSS nmos_rvt L=2e-08 W=8.1e-08 nfin=3
M6 noxref_9 A VSS VSS nmos_rvt L=2e-08 W=8.1e-08 nfin=3
M7 Y B noxref_9 VSS nmos_rvt L=2e-08 W=8.1e-08 nfin=3
M8 N_M8_d A VDD VDD pmos_rvt L=2e-08 W=8.1e-08 nfin=3
M9 N_M0_d B N_M8_d VDD pmos_rvt L=2e-08 W=8.1e-08 nfin=3
M10 VDD B noxref_6 VDD pmos_rvt L=2e-08 W=8.1e-08 nfin=3
M11 noxref_6 A VDD VDD pmos_rvt L=2e-08 W=8.1e-08 nfin=3
M12 Y N_M0_d noxref_6 VDD pmos_rvt L=2e-08 W=8.1e-08 nfin=3
M13 Y N_M0_d noxref_6 VDD pmos_rvt L=2e-08 W=8.1e-08 nfin=3
M14 noxref_6 A VDD VDD pmos_rvt L=2e-08 W=8.1e-08 nfin=3
M15 VDD B noxref_6 VDD pmos_rvt L=2e-08 W=8.1e-08 nfin=3
.ENDS

.SUBCKT XOR2x2_ASAP7_75t_R A B VDD VSS Y
M0 noxref_7 N_M0_g N_M0_s VSS nmos_rvt L=2e-08 W=8.1e-08 nfin=3
M1 VSS B noxref_7 VSS nmos_rvt L=2e-08 W=8.1e-08 nfin=3
M2 noxref_7 A VSS VSS nmos_rvt L=2e-08 W=8.1e-08 nfin=3
M3 N_M3_d A N_M0_g VSS nmos_rvt L=2e-08 W=8.1e-08 nfin=3
M4 VSS B N_M3_d VSS nmos_rvt L=2e-08 W=8.1e-08 nfin=3
M5 Y N_M0_s VSS VSS nmos_rvt L=2e-08 W=8.1e-08 nfin=3
M6 Y N_M0_s VSS VSS nmos_rvt L=2e-08 W=8.1e-08 nfin=3
M7 VDD N_M0_g N_M0_s VDD pmos_rvt L=2e-08 W=8.1e-08 nfin=3
M8 noxref_10 B VDD VDD pmos_rvt L=2e-08 W=8.1e-08 nfin=3
M9 N_M0_s A noxref_10 VDD pmos_rvt L=2e-08 W=8.1e-08 nfin=3
M10 N_M0_g A VDD VDD pmos_rvt L=2e-08 W=5.4e-08 nfin=2
M11 VDD B N_M0_g VDD pmos_rvt L=2e-08 W=5.4e-08 nfin=2
M12 Y N_M0_s VDD VDD pmos_rvt L=2e-08 W=8.1e-08 nfin=3
M13 Y N_M0_s VDD VDD pmos_rvt L=2e-08 W=8.1e-08 nfin=3
.ENDS

.SUBCKT XOR2xp5_ASAP7_75t_R A B VDD VSS Y
M0 N_M0_d A VSS VSS nmos_rvt L=2e-08 W=5.4e-08 nfin=2
M1 VSS B N_M0_d VSS nmos_rvt L=2e-08 W=5.4e-08 nfin=2
M2 noxref_8 B Y VSS nmos_rvt L=2e-08 W=8.1e-08 nfin=3
M3 VSS A noxref_8 VSS nmos_rvt L=2e-08 W=8.1e-08 nfin=3
M4 Y N_M0_d VSS VSS nmos_rvt L=2e-08 W=8.1e-08 nfin=3
M5 N_M5_d A VDD VDD pmos_rvt L=2e-08 W=8.1e-08 nfin=3
M6 N_M0_d B N_M5_d VDD pmos_rvt L=2e-08 W=8.1e-08 nfin=3
M7 VDD B noxref_6 VDD pmos_rvt L=2e-08 W=8.1e-08 nfin=3
M8 noxref_6 A VDD VDD pmos_rvt L=2e-08 W=8.1e-08 nfin=3
M9 Y N_M0_d noxref_6 VDD pmos_rvt L=2e-08 W=8.1e-08 nfin=3
.ENDS

* Physical well/substrate tap, no transistor devices.
.SUBCKT TAPCELL_ASAP7_75t_R VDD VSS
.ENDS TAPCELL_ASAP7_75t_R

* Physical filler without active devices.
.SUBCKT FILLER_ASAP7_75t_R VDD VSS
.ENDS FILLER_ASAP7_75t_R

* Physical filler without active devices.
.SUBCKT FILLERxp5_ASAP7_75t_R VDD VSS
.ENDS FILLERxp5_ASAP7_75t_R
