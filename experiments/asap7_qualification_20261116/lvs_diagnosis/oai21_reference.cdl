* OAI21x1 transistor topology from independently published official xACT PEX.
.SUBCKT OAI21x1_ASAP7_75t_R A1 A2 B VDD VSS Y
M0 noxref_6 B Y VSS nmos_rvt L=2e-08 W=8.1e-08 nfin=3
M1 VSS A1 noxref_6 VSS nmos_rvt L=2e-08 W=8.1e-08 nfin=3
M2 noxref_6 A2 VSS VSS nmos_rvt L=2e-08 W=8.1e-08 nfin=3
M3 noxref_6 A2 VSS VSS nmos_rvt L=2e-08 W=8.1e-08 nfin=3
M4 VSS A1 noxref_6 VSS nmos_rvt L=2e-08 W=8.1e-08 nfin=3
M5 noxref_6 B Y VSS nmos_rvt L=2e-08 W=8.1e-08 nfin=3
M6 Y B VDD VDD pmos_rvt L=2e-08 W=8.1e-08 nfin=3
M7 Y A1 noxref_8 VDD pmos_rvt L=2e-08 W=8.1e-08 nfin=3
M8 noxref_8 A2 VDD VDD pmos_rvt L=2e-08 W=8.1e-08 nfin=3
M9 noxref_9 A2 VDD VDD pmos_rvt L=2e-08 W=8.1e-08 nfin=3
M10 Y A1 noxref_9 VDD pmos_rvt L=2e-08 W=8.1e-08 nfin=3
M11 Y B VDD VDD pmos_rvt L=2e-08 W=8.1e-08 nfin=3
.ENDS
